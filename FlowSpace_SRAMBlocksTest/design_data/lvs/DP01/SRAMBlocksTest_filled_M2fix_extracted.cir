* Extracted by KLayout with SG13G2 LVS runset on : 17/10/2025 11:28

.SUBCKT DP01 vss vdd_block vdd_periph in_srout1 out_srout1 out_srin in_srin
+ clk2 out_latch2 out_latch1 clk1 out_shift1 out_l2s in_shift1 out_srout2
+ in_shift2 in_srout2 in_latch2 in_latch1 out_shift2
X$2 vss vdd_periph out_l2s out_shift1 out_srout1 out_srin clk1 out_latch1
+ in_latch1 in_shift1 in_srin in_srout1 vdd_block in_latch2 in_srout2 clk2
+ in_srin in_shift2 out_latch2 out_srout2 out_l2s out_shift2 out_srin
+ DP8TBlock_512x32_342A4WE_Test
.ENDS DP01

.SUBCKT DP8TBlock_512x32_342A4WE_Test vss vdd_periph out_l2s1 out_shift1
+ out_srout1 out_srin1 clk1 out_latch1 in_latch1 in_shift1 in_srin1 in_srout1
+ vdd_block in_latch2 in_srout2 clk2 in_srin2 in_shift2 out_latch2 out_srout2
+ out_l2s2 out_shift2 out_srin2
X$1 vss clk1 \$65 \$16 \$66 \$17 \$67 \$18 \$68 \$19 \$69 \$20 \$70 \$21 \$99
+ \$22 \$71 \$23 \$72 \$73 \$24 \$74 \$25 \$75 \$26 \$76 \$27 \$77 \$28 \$78
+ \$29 \$79 \$30 \$80 \$31 \$81 \$82 \$32 \$83 \$33 \$84 \$34 \$85 \$35 \$86
+ \$36 \$87 \$37 \$101 \$38 \$88 \$39 \$89 \$90 \$40 \$91 \$41 \$92 \$42 \$93
+ \$43 \$94 \$44 \$95 \$45 \$96 \$46 \$97 \$47 \$98 \$64 \$63 vdd_block \$61
+ \$62 \$58 \$60 \$59 \$57 \$56 \$151 \$150 \$102 \$103 \$149 \$148 \$147 \$146
+ \$104 \$130 \$153 \$154 \$155 \$156 \$176 \$177 \$178 \$134 \$158 \$159 \$160
+ \$161 \$179 \$180 \$181 \$139 \$163 \$164 \$165 \$166 \$183 \$184 \$185 \$143
+ \$168 \$169 \$170 \$171 \$186 \$187 \$188 \$129 \$131 \$105 \$106 \$107 \$108
+ \$109 \$110 \$132 \$133 \$135 \$111 \$112 \$113 \$114 \$115 \$116 \$136 \$138
+ \$140 \$117 \$118 \$119 \$120 \$121 \$122 \$141 \$142 \$144 \$123 \$124 \$125
+ \$126 \$127 \$128 \$145 clk2 DP8TBlock_512x32_342A4WE
X$2 vss vdd_periph out_shift2 out_l2s2 in_latch2 out_latch2 clk2 out_srin2
+ \$196 DP8TTimingOut_2SL
X$5 vss in_shift1 \$48 vdd_periph \$49 in_latch1 \$65 \$66 \$67 \$68 \$69 \$70
+ \$99 \$71 \$72 DP8TTimingIn_9SL
X$6 vss out_shift1 out_l2s1 \$5 vdd_periph \$4 out_latch1 \$16 \$17 \$18 \$19
+ \$20 \$21 \$22 \$23 DP8TTimingOut_8SL
X$7 vss in_shift2 \$173 vdd_periph \$167 in_latch2 \$145 \$128 \$127 \$126
+ \$125 \$124 \$123 \$144 \$142 DP8TTimingIn_9SL
X$8 vss out_shift2 out_l2s2 \$195 vdd_periph \$196 out_latch2 \$188 \$187 \$186
+ \$171 \$170 \$169 \$168 \$143 DP8TTimingOut_8SL
X$9 vss in_shift2 \$157 vdd_periph in_srout2 in_latch2 \$132 \$110 \$109 \$108
+ \$107 \$106 \$105 \$131 \$129 DP8TTimingIn_9SL
X$10 vss out_shift2 out_l2s2 out_srout2 vdd_periph \$191 out_latch2 \$178 \$177
+ \$176 \$156 \$155 \$154 \$153 \$130 DP8TTimingOut_8SL
X$11 vss in_shift2 \$167 vdd_periph \$162 in_latch2 \$141 \$122 \$121 \$120
+ \$119 \$118 \$117 \$140 \$138 DP8TTimingIn_9SL
X$12 vss out_shift2 out_l2s2 \$192 vdd_periph \$195 out_latch2 \$185 \$184
+ \$183 \$166 \$165 \$164 \$163 \$139 DP8TTimingOut_8SL
X$13 vss in_shift2 \$162 vdd_periph \$157 in_latch2 \$136 \$116 \$115 \$114
+ \$113 \$112 \$111 \$135 \$133 DP8TTimingIn_9SL
X$14 vss out_shift2 out_l2s2 \$191 vdd_periph \$192 out_latch2 \$181 \$180
+ \$179 \$161 \$160 \$159 \$158 \$134 DP8TTimingOut_8SL
X$15 vss in_shift1 \$49 vdd_periph \$50 in_latch1 \$73 \$74 \$75 \$76 \$77 \$78
+ \$79 \$80 \$81 DP8TTimingIn_9SL
X$16 vss out_shift1 out_l2s1 \$8 vdd_periph \$5 out_latch1 \$24 \$25 \$26 \$27
+ \$28 \$29 \$30 \$31 DP8TTimingOut_8SL
X$17 vss in_shift1 \$50 vdd_periph \$52 in_latch1 \$82 \$83 \$84 \$85 \$86 \$87
+ \$101 \$88 \$89 DP8TTimingIn_9SL
X$18 vss out_shift1 out_l2s1 \$9 vdd_periph \$8 out_latch1 \$32 \$33 \$34 \$35
+ \$36 \$37 \$38 \$39 DP8TTimingOut_8SL
X$19 vss in_shift1 \$52 vdd_periph in_srout1 in_latch1 \$90 \$91 \$92 \$93 \$94
+ \$95 \$96 \$97 \$98 DP8TTimingIn_9SL
X$20 vss out_shift1 out_l2s1 out_srout1 vdd_periph \$9 out_latch1 \$40 \$41
+ \$42 \$43 \$44 \$45 \$46 \$47 DP8TTimingOut_8SL
X$21 vss in_shift1 in_srin1 vdd_periph \$48 in_latch1 \$56 \$57 \$58 \$59 \$60
+ \$61 \$62 \$63 \$64 DP8TTimingIn_9SF
X$25 vss vdd_periph out_shift1 out_l2s1 in_latch1 out_latch1 clk1 out_srin1 \$4
+ DP8TTimingOut_2SL
X$27 vss in_shift2 in_srin2 vdd_periph \$173 in_latch2 \$151 \$150 \$102 \$149
+ \$148 \$147 \$103 \$146 \$104 DP8TTimingIn_9SF
.ENDS DP8TBlock_512x32_342A4WE_Test

.SUBCKT DP8TTimingOut_2SL vss vdd sr_shift l2s o[0] o[1] sr_latch sr_in sr_out
X$1 vss \$11 \$10 sr_shift vdd dff_x1
X$2 vss o[0] \$12 sr_latch vdd dff_x1
X$3 vdd vss l2s sr_in \$12 \$11 mux2_x1
X$4 vdd vss l2s \$10 \$15 \$14 mux2_x1
X$5 vss \$14 sr_out sr_shift vdd dff_x1
X$6 vss o[1] \$15 sr_latch vdd dff_x1
.ENDS DP8TTimingOut_2SL

.SUBCKT DP8TTimingOut_8SL vss sr_shift l2s sr_out vdd sr_in sr_latch o[0] o[1]
+ o[2] o[3] o[4] o[5] o[6] o[7]
X$1 vss \$9 \$10 sr_shift vdd dff_x1
X$2 vss o[0] \$25 sr_latch vdd dff_x1
X$3 vdd vss l2s sr_in \$25 \$9 mux2_x1
X$4 vdd vss l2s \$10 \$5 \$11 mux2_x1
X$5 vss \$11 \$12 sr_shift vdd dff_x1
X$6 vss o[1] \$5 sr_latch vdd dff_x1
X$7 vss \$13 \$14 sr_shift vdd dff_x1
X$8 vss o[2] \$26 sr_latch vdd dff_x1
X$9 vdd vss l2s \$12 \$26 \$13 mux2_x1
X$10 vdd vss l2s \$14 \$6 \$15 mux2_x1
X$11 vss \$15 \$16 sr_shift vdd dff_x1
X$12 vss o[3] \$6 sr_latch vdd dff_x1
X$13 vss \$17 \$18 sr_shift vdd dff_x1
X$14 vss o[4] \$28 sr_latch vdd dff_x1
X$15 vdd vss l2s \$16 \$28 \$17 mux2_x1
X$16 vdd vss l2s \$18 \$7 \$19 mux2_x1
X$17 vss \$19 \$20 sr_shift vdd dff_x1
X$18 vss o[5] \$7 sr_latch vdd dff_x1
X$19 vss \$21 \$22 sr_shift vdd dff_x1
X$20 vss o[6] \$29 sr_latch vdd dff_x1
X$21 vdd vss l2s \$20 \$29 \$21 mux2_x1
X$22 vdd vss l2s \$22 \$8 \$23 mux2_x1
X$23 vss \$23 sr_out sr_shift vdd dff_x1
X$24 vss o[7] \$8 sr_latch vdd dff_x1
.ENDS DP8TTimingOut_8SL

.SUBCKT DP8TTimingIn_9SL vss sr_shift sr_in vdd sr_out sr_latch i[0] i[1] i[2]
+ i[3] i[4] i[5] i[6] i[7] i[8]
X$1 vss sr_in \$5 sr_shift vdd dff_x1
X$2 vss \$5 i[0] sr_latch vdd dff_x1
X$3 vss \$5 \$6 sr_shift vdd dff_x1
X$4 vss \$6 i[1] sr_latch vdd dff_x1
X$5 vss \$6 \$7 sr_shift vdd dff_x1
X$6 vss \$7 i[2] sr_latch vdd dff_x1
X$7 vss \$7 \$8 sr_shift vdd dff_x1
X$8 vss \$8 i[3] sr_latch vdd dff_x1
X$9 vss \$8 \$9 sr_shift vdd dff_x1
X$10 vss \$9 i[4] sr_latch vdd dff_x1
X$11 vss \$9 \$10 sr_shift vdd dff_x1
X$12 vss \$10 i[5] sr_latch vdd dff_x1
X$13 vss \$10 \$11 sr_shift vdd dff_x1
X$14 vss \$11 i[6] sr_latch vdd dff_x1
X$15 vss \$11 \$12 sr_shift vdd dff_x1
X$16 vss \$12 i[7] sr_latch vdd dff_x1
X$17 vss \$12 sr_out sr_shift vdd dff_x1
X$18 vss sr_out i[8] sr_latch vdd dff_x1
.ENDS DP8TTimingIn_9SL

.SUBCKT DP8TTimingIn_9SF vss sr_shift sr_in vdd sr_out sr_latch i[8] i[7] i[6]
+ i[5] i[4] i[3] i[2] i[1] i[0]
X$1 vss sr_in \$5 sr_shift vdd dff_x1
X$2 vss \$5 i[8] sr_latch vdd dff_x1
X$3 vss \$5 \$6 sr_shift vdd dff_x1
X$4 vss \$6 i[7] sr_latch vdd dff_x1
X$5 vss \$6 \$7 sr_shift vdd dff_x1
X$6 vss \$7 i[6] sr_latch vdd dff_x1
X$7 vss \$7 \$8 sr_shift vdd dff_x1
X$8 vss \$8 i[5] sr_latch vdd dff_x1
X$9 vss \$8 \$9 sr_shift vdd dff_x1
X$10 vss \$9 i[4] sr_latch vdd dff_x1
X$11 vss \$9 \$10 sr_shift vdd dff_x1
X$12 vss \$10 i[3] sr_latch vdd dff_x1
X$13 vss \$10 \$11 sr_shift vdd dff_x1
X$14 vss \$11 i[2] sr_latch vdd dff_x1
X$15 vss \$11 \$12 sr_shift vdd dff_x1
X$16 vss \$12 i[1] sr_latch vdd dff_x1
X$17 vss \$12 sr_out sr_shift vdd dff_x1
X$18 vss sr_out i[0] sr_latch vdd dff_x1
.ENDS DP8TTimingIn_9SF

.SUBCKT DP8TBlock_512x32_342A4WE vss clk1 d1[0] q1[0] d1[1] q1[1] d1[2] q1[2]
+ d1[3] q1[3] d1[4] q1[4] d1[5] q1[5] d1[6] q1[6] d1[7] q1[7] we1[0] d1[8]
+ q1[8] d1[9] q1[9] d1[10] q1[10] d1[11] q1[11] d1[12] q1[12] d1[13] q1[13]
+ d1[14] q1[14] d1[15] q1[15] we1[1] d1[16] q1[16] d1[17] q1[17] d1[18] q1[18]
+ d1[19] q1[19] d1[20] q1[20] d1[21] q1[21] d1[22] q1[22] d1[23] q1[23] we1[2]
+ d1[24] q1[24] d1[25] q1[25] d1[26] q1[26] d1[27] q1[27] d1[28] q1[28] d1[29]
+ q1[29] d1[30] q1[30] d1[31] q1[31] we1[3] a1[0] a1[1] vdd a1[3] a1[2] a1[6]
+ a1[4] a1[5] a1[7] a1[8] a2[8] a2[7] a2[6] a2[2] a2[5] a2[4] a2[3] a2[1] a2[0]
+ q2[0] q2[1] q2[2] q2[3] q2[4] q2[5] q2[6] q2[7] q2[8] q2[9] q2[10] q2[11]
+ q2[12] q2[13] q2[14] q2[15] q2[16] q2[17] q2[18] q2[19] q2[20] q2[21] q2[22]
+ q2[23] q2[24] q2[25] q2[26] q2[27] q2[28] q2[29] q2[30] q2[31] we2[0] d2[0]
+ d2[1] d2[2] d2[3] d2[4] d2[5] d2[6] d2[7] we2[1] d2[8] d2[9] d2[10] d2[11]
+ d2[12] d2[13] d2[14] d2[15] we2[2] d2[16] d2[17] d2[18] d2[19] d2[20] d2[21]
+ d2[22] d2[23] we2[3] d2[24] d2[25] d2[26] d2[27] d2[28] d2[29] d2[30] d2[31]
+ clk2
X$1 vss clk1 \$71 \$72 vdd \$75 a1[0] \$81 \$82 a1[1] \$80 \$83 a1[2] a1[3]
+ a1[4] a1[5] a1[6] a1[7] a1[8] DP8TRowPeriphery_3_4_2_wl1
X$2 vss d1[0] q1[0] d1[1] q1[1] d1[2] q1[2] d1[3] q1[3] d1[4] q1[4] d1[5] q1[5]
+ d1[6] q1[6] d1[7] q1[7] we1[0] d1[8] q1[8] d1[9] q1[9] d1[10] q1[10] d1[11]
+ q1[11] d1[12] q1[12] d1[13] q1[13] d1[14] q1[14] d1[15] q1[15] we1[1] d1[16]
+ q1[16] d1[17] q1[17] d1[18] q1[18] d1[19] q1[19] \$71 \$72 d1[20] q1[20]
+ d1[21] q1[21] d1[22] q1[22] d1[23] q1[23] we1[2] d1[24] q1[24] d1[25] q1[25]
+ d1[26] q1[26] d1[27] q1[27] d1[28] q1[28] d1[29] q1[29] d1[30] q1[30] d1[31]
+ q1[31] we1[3] vdd \$81 \$82 \$80 \$83 we2[0] q2[0] d2[0] q2[1] d2[1] q2[2]
+ d2[2] q2[3] d2[3] q2[4] d2[4] q2[5] d2[5] q2[6] d2[6] q2[7] d2[7] we2[1]
+ q2[8] d2[8] q2[9] d2[9] q2[10] d2[10] q2[11] d2[11] \$452 \$453 q2[12] d2[12]
+ q2[13] d2[13] q2[14] d2[14] q2[15] d2[15] \$343 \$340 \$341 \$342 we2[2]
+ q2[16] d2[16] q2[17] d2[17] q2[18] d2[18] q2[19] d2[19] q2[20] d2[20] q2[21]
+ d2[21] q2[22] d2[22] q2[23] d2[23] we2[3] q2[24] d2[24] q2[25] d2[25] q2[26]
+ d2[26] q2[27] d2[27] q2[28] d2[28] q2[29] d2[29] q2[30] d2[30] q2[31] d2[31]
+ DP8TColumnBlock_128R32B4M4W
X$3 vss clk2 \$453 \$452 vdd \$286 a2[0] \$340 \$341 a2[1] \$342 \$343 a2[2]
+ a2[3] a2[4] a2[5] a2[6] a2[7] a2[8] DP8TRowPeriphery_3_4_2_wl2
.ENDS DP8TBlock_512x32_342A4WE

.SUBCKT mux2_x1 vdd vss cmd i0 i1 q
M$1 \$1 cmd vss vss sg13_lv_nmos L=0.13u W=0.78u AS=0.2652p AD=0.1482p PS=2.24u
+ PD=1.16u
M$2 vss i0 \$9 vss sg13_lv_nmos L=0.13u W=0.78u AS=0.1482p AD=0.1482p PS=1.16u
+ PD=1.16u
M$3 \$9 \$1 \$6 vss sg13_lv_nmos L=0.13u W=0.78u AS=0.1482p AD=0.195p PS=1.16u
+ PD=1.28u
M$4 \$6 cmd \$10 vss sg13_lv_nmos L=0.13u W=0.78u AS=0.195p AD=0.1482p PS=1.28u
+ PD=1.16u
M$5 \$10 i1 vss vss sg13_lv_nmos L=0.13u W=0.78u AS=0.1482p AD=0.2092p PS=1.16u
+ PD=1.48u
M$6 vss \$6 q vss sg13_lv_nmos L=0.13u W=1.07u AS=0.2092p AD=0.3638p PS=1.48u
+ PD=2.82u
M$7 \$1 cmd vdd vdd sg13_lv_pmos L=0.13u W=0.78u AS=0.2652p AD=0.1482p PS=2.24u
+ PD=1.16u
M$8 vdd i0 \$11 vdd sg13_lv_pmos L=0.13u W=0.78u AS=0.1482p AD=0.1482p PS=1.16u
+ PD=1.16u
M$9 \$11 cmd \$6 vdd sg13_lv_pmos L=0.13u W=0.78u AS=0.1482p AD=0.195p PS=1.16u
+ PD=1.28u
M$10 \$6 \$1 \$12 vdd sg13_lv_pmos L=0.13u W=0.78u AS=0.195p AD=0.1482p
+ PS=1.28u PD=1.16u
M$11 vdd i1 \$12 vdd sg13_lv_pmos L=0.13u W=0.78u AS=0.2075p AD=0.1482p
+ PS=1.47u PD=1.16u
M$12 vdd \$6 q vdd sg13_lv_pmos L=0.13u W=1.06u AS=0.2075p AD=0.3604p PS=1.47u
+ PD=2.8u
.ENDS mux2_x1

.SUBCKT DP8TRowPeriphery_3_4_2_wl2 vss clk columnclk we_en vdd precharge_n a[0]
+ mux[0] mux[1] a[1] mux[2] mux[3] a[2] a[3] a[4] a[5] a[6] a[7] a[8]
X$1 vss vdd clk \$7 wl_en precharge_n columnclk we_en DP8TClockGenerator_8S1R
X$2 vss vdd a[2] a[3] a[4] \$7 a[5] a[6] a[7] a[8] DP8TRowDecoder_3_4B_wl2
X$3 vss vdd a[0] a[1] mux[0] mux[1] mux[2] mux[3] \$7 DP8TLatchedDecoder_2A2R
.ENDS DP8TRowPeriphery_3_4_2_wl2

.SUBCKT DP8TColumnBlock_128R32B4M4W vss d1[0] q1[0] d1[1] q1[1] d1[2] q1[2]
+ d1[3] q1[3] d1[4] q1[4] d1[5] q1[5] d1[6] q1[6] d1[7] q1[7] we1[0] d1[8]
+ q1[8] d1[9] q1[9] d1[10] q1[10] d1[11] q1[11] d1[12] q1[12] d1[13] q1[13]
+ d1[14] q1[14] d1[15] q1[15] we1[1] d1[16] q1[16] d1[17] q1[17] d1[18] q1[18]
+ d1[19] q1[19] clk1 we_en1 d1[20] q1[20] d1[21] q1[21] d1[22] q1[22] d1[23]
+ q1[23] we1[2] d1[24] q1[24] d1[25] q1[25] d1[26] q1[26] d1[27] q1[27] d1[28]
+ q1[28] d1[29] q1[29] d1[30] q1[30] d1[31] q1[31] we1[3] vdd mux1[0] mux1[1]
+ mux1[2] mux1[3] we2[0] q2[0] d2[0] q2[1] d2[1] q2[2] d2[2] q2[3] d2[3] q2[4]
+ d2[4] q2[5] d2[5] q2[6] d2[6] q2[7] d2[7] we2[1] q2[8] d2[8] q2[9] d2[9]
+ q2[10] d2[10] q2[11] d2[11] we_en2 clk2 q2[12] d2[12] q2[13] d2[13] q2[14]
+ d2[14] q2[15] d2[15] mux2[3] mux2[0] mux2[1] mux2[2] we2[2] q2[16] d2[16]
+ q2[17] d2[17] q2[18] d2[18] q2[19] d2[19] q2[20] d2[20] q2[21] d2[21] q2[22]
+ d2[22] q2[23] d2[23] we2[3] q2[24] d2[24] q2[25] d2[25] q2[26] d2[26] q2[27]
+ d2[27] q2[28] d2[28] q2[29] d2[29] q2[30] d2[30] q2[31] d2[31]
X$1 vss d1[8] q1[8] d1[9] q1[9] d1[10] q1[10] d1[11] q1[11] d1[12] q1[12]
+ d1[13] q1[13] d1[14] q1[14] d1[15] q1[15] we1[1] clk1 we_en1 \$441 \$440
+ \$437 \$436 \$433 \$432 \$429 \$428 \$425 \$424 \$421 \$420 \$417 \$416 \$413
+ \$412 \$409 \$408 \$405 \$404 \$401 \$400 \$397 \$396 \$393 \$392 \$389 \$388
+ \$385 \$384 \$381 \$380 mux1[0] vdd \$377 \$376 \$373 \$372 \$369 \$368 \$365
+ \$364 \$361 \$360 \$357 \$356 \$353 \$352 \$349 \$348 \$345 \$344 \$341 \$340
+ \$337 \$336 \$333 \$332 \$329 \$328 \$325 \$324 \$461 \$460 \$457 \$456
+ mux1[1] mux1[2] mux1[3] \$924 \$923 \$921 \$920 \$918 \$917 \$915 \$936 \$934
+ \$933 \$931 \$930 \$928 \$927 \$948 \$949 \$946 \$945 \$943 \$942 \$940 \$939
+ \$937 \$960 \$958 \$957 \$955 \$954 \$952 \$951 \$971 \$972 \$969 \$968 \$966
+ \$965 \$963 \$962 \$984 \$983 \$981 \$980 \$978 \$977 \$975 \$974 \$996 \$995
+ \$993 \$992 \$990 \$989 \$987 \$986 \$1008 \$1007 \$1005 \$1004 \$1002 \$1001
+ \$999 \$998 \$1012 \$1011 we_en2 clk2 we2[1] q2[8] d2[8] q2[9] d2[9] q2[10]
+ d2[10] q2[11] d2[11] mux2[3] mux2[2] mux2[0] mux2[1] q2[12] d2[12] q2[13]
+ d2[13] q2[14] d2[14] q2[15] d2[15] DP8TColumn_128R8B4M
X$2 vss d1[0] q1[0] d1[1] q1[1] d1[2] q1[2] d1[3] q1[3] d1[4] q1[4] d1[5] q1[5]
+ d1[6] q1[6] d1[7] q1[7] we1[0] clk1 we_en1 \$323 \$322 \$319 \$318 \$315
+ \$314 \$311 \$310 \$307 \$306 \$303 \$302 \$299 \$298 \$295 \$294 \$291 \$290
+ \$287 \$286 \$283 \$282 \$279 \$278 \$275 \$274 \$271 \$270 \$267 \$266 \$263
+ \$262 mux1[0] vdd \$259 \$258 \$255 \$254 \$251 \$250 \$247 \$246 \$243 \$242
+ \$239 \$238 \$235 \$234 \$231 \$230 \$227 \$226 \$223 \$222 \$219 \$218 \$215
+ \$214 \$211 \$208 \$453 \$452 \$449 \$448 \$445 \$444 mux1[1] mux1[2] mux1[3]
+ \$828 \$829 \$831 \$827 \$825 \$824 \$822 \$821 \$842 \$841 \$839 \$838 \$836
+ \$835 \$833 \$832 \$852 \$851 \$849 \$848 \$846 \$845 \$843 \$864 \$866 \$863
+ \$861 \$860 \$858 \$857 \$855 \$854 \$876 \$875 \$873 \$872 \$870 \$869 \$867
+ \$888 \$890 \$887 \$885 \$884 \$882 \$881 \$879 \$878 \$900 \$899 \$897 \$896
+ \$894 \$893 \$891 \$912 \$914 \$911 \$909 \$908 \$906 \$905 \$903 \$902
+ we_en2 clk2 we2[0] q2[0] d2[0] q2[1] d2[1] q2[2] d2[2] q2[3] d2[3] mux2[3]
+ mux2[2] mux2[0] mux2[1] q2[4] d2[4] q2[5] d2[5] q2[6] d2[6] q2[7] d2[7]
+ DP8TColumn_128R8B4M
X$3 vss d1[16] q1[16] d1[17] q1[17] d1[18] q1[18] d1[19] q1[19] d1[20] q1[20]
+ d1[21] q1[21] d1[22] q1[22] d1[23] q1[23] we1[2] clk1 we_en1 \$468 \$469
+ \$472 \$473 \$476 \$477 \$480 \$481 \$484 \$485 \$488 \$489 \$492 \$493 \$496
+ \$497 \$500 \$501 \$504 \$505 \$508 \$509 \$512 \$513 \$516 \$517 \$520 \$521
+ \$524 \$525 \$528 \$529 mux1[0] vdd \$532 \$533 \$536 \$537 \$540 \$541 \$544
+ \$545 \$548 \$549 \$552 \$553 \$556 \$557 \$560 \$561 \$564 \$565 \$568 \$569
+ \$572 \$573 \$576 \$577 \$580 \$581 \$584 \$585 \$588 \$589 \$592 \$590
+ mux1[1] mux1[2] mux1[3] \$1009 \$1021 \$1019 \$1018 \$1016 \$1015 \$1013
+ \$1032 \$1034 \$1031 \$1029 \$1028 \$1026 \$1025 \$1023 \$1022 \$1044 \$1043
+ \$1041 \$1040 \$1038 \$1037 \$1035 \$1056 \$1058 \$1055 \$1053 \$1052 \$1050
+ \$1049 \$1047 \$1046 \$1068 \$1067 \$1065 \$1064 \$1062 \$1061 \$1059 \$1080
+ \$1082 \$1079 \$1077 \$1076 \$1074 \$1073 \$1071 \$1070 \$1092 \$1091 \$1089
+ \$1088 \$1086 \$1085 \$1083 \$1104 \$1106 \$1103 \$1101 \$1100 \$1098 \$1097
+ \$1095 \$1094 we_en2 clk2 we2[2] q2[16] d2[16] q2[17] d2[17] q2[18] d2[18]
+ q2[19] d2[19] mux2[3] mux2[2] mux2[0] mux2[1] q2[20] d2[20] q2[21] d2[21]
+ q2[22] d2[22] q2[23] d2[23] DP8TColumn_128R8B4M
X$4 vss d1[24] q1[24] d1[25] q1[25] d1[26] q1[26] d1[27] q1[27] d1[28] q1[28]
+ d1[29] q1[29] d1[30] q1[30] d1[31] q1[31] we1[3] clk1 we_en1 \$582 \$578
+ \$570 \$566 \$558 \$554 \$546 \$542 \$534 \$530 \$522 \$518 \$510 \$506 \$498
+ \$494 \$486 \$482 \$474 \$470 \$465 \$464 \$459 \$454 \$447 \$443 \$435 \$431
+ \$423 \$419 \$411 \$407 mux1[0] vdd \$399 \$395 \$387 \$383 \$375 \$371 \$363
+ \$359 \$351 \$347 \$339 \$335 \$327 \$321 \$313 \$309 \$301 \$297 \$289 \$285
+ \$277 \$273 \$265 \$261 \$253 \$249 \$241 \$237 \$229 \$225 \$217 \$213
+ mux1[1] mux1[2] mux1[3] \$1116 \$1117 \$1113 \$1112 \$1110 \$1109 \$1107
+ \$1128 \$1126 \$1125 \$1123 \$1122 \$1120 \$1119 \$1137 \$1136 \$1134 \$1133
+ \$1131 \$1130 \$1146 \$1145 \$1143 \$1142 \$1140 \$1139 \$1155 \$1154 \$1152
+ \$1151 \$1149 \$1148 \$1165 \$1164 \$1162 \$1161 \$1159 \$1158 \$1156 \$1176
+ \$1174 \$1173 \$1171 \$1170 \$1168 \$1167 \$1187 \$1188 \$1185 \$1184 \$1182
+ \$1181 \$1179 \$1178 \$1199 \$1198 \$1196 \$1195 \$1193 \$1192 \$1190 \$1189
+ \$1201 \$1202 we_en2 clk2 we2[3] q2[24] d2[24] q2[25] d2[25] q2[26] d2[26]
+ q2[27] d2[27] mux2[3] mux2[2] mux2[0] mux2[1] q2[28] d2[28] q2[29] d2[29]
+ q2[30] d2[30] q2[31] d2[31] DP8TColumn_128R8B4M
.ENDS DP8TColumnBlock_128R32B4M4W

.SUBCKT DP8TRowPeriphery_3_4_2_wl1 vss clk columnclk we_en vdd precharge_n a[0]
+ mux[0] mux[1] a[1] mux[2] mux[3] a[2] a[3] a[4] a[5] a[6] a[7] a[8]
X$1 vss vdd clk \$7 wl_en precharge_n columnclk we_en DP8TClockGenerator_8S1R
X$2 vss vdd a[0] a[1] mux[0] mux[1] mux[2] mux[3] \$7 DP8TLatchedDecoder_2A2R
X$3 vss vdd a[2] a[3] a[4] a[5] \$7 a[6] a[7] a[8] DP8TRowDecoder_3_4B_wl1
.ENDS DP8TRowPeriphery_3_4_2_wl1

.SUBCKT DP8TRowDecoder_3_4B_wl2 vss vdd a[0] a[1] a[2] clk a[3] a[4] a[5] a[6]
X$1 vss vdd \$18 \$36 \$47 \$35 \$94 \$48 \$30 \$156 \$31 \$208 \$7 \$19 \$278
+ \$327 \$389 \$443 \$503 \$557 \$616 \$662 \$741 \$783 \$842 \$897 clk a[0]
+ a[1] a[2] a[3] a[4] a[5] a[6] DP8TRowPredecoders_3_4B_wl2
.ENDS DP8TRowDecoder_3_4B_wl2

.SUBCKT DP8TColumn_128R8B4M vss d1[0] q1[0] d1[1] q1[1] d1[2] q1[2] d1[3] q1[3]
+ d1[4] q1[4] d1[5] q1[5] d1[6] q1[6] d1[7] q1[7] we1 clk1 we_en1 bl1[0]
+ bl1_n[0] bl1_n[1] bl1[1] bl1[2] bl1_n[2] bl1_n[3] bl1[3] bl1[4] bl1_n[4]
+ bl1_n[5] bl1[5] bl1[6] bl1_n[6] bl1_n[7] bl1[7] bl1[8] bl1_n[8] bl1_n[9]
+ bl1[9] bl1[10] bl1_n[10] bl1_n[11] bl1[11] bl1[12] bl1_n[12] bl1_n[13]
+ bl1[13] bl1[14] bl1_n[14] bl1_n[15] bl1[15] mux1[0] vdd bl1[16] bl1_n[16]
+ bl1_n[17] bl1[17] bl1[18] bl1_n[18] bl1_n[19] bl1[19] bl1[20] bl1_n[20]
+ bl1_n[21] bl1[21] bl1[22] bl1_n[22] bl1_n[23] bl1[23] bl1[24] bl1_n[24]
+ bl1_n[25] bl1[25] bl1[26] bl1_n[26] bl1_n[27] bl1[27] bl1[28] bl1_n[28]
+ bl1_n[29] bl1[29] bl1[30] bl1_n[30] bl1_n[31] bl1[31] mux1[1] mux1[2] mux1[3]
+ bl2[0] bl2_n[0] bl2_n[1] bl2[1] bl2[2] bl2_n[2] bl2_n[3] bl2[3] bl2[4]
+ bl2_n[4] bl2_n[5] bl2[5] bl2[6] bl2_n[6] bl2_n[7] bl2[7] bl2[8] bl2_n[8]
+ bl2_n[9] bl2[9] bl2[10] bl2_n[10] bl2_n[11] bl2[11] bl2[12] bl2_n[12]
+ bl2_n[13] bl2[13] bl2[14] bl2_n[14] bl2_n[15] bl2[15] bl2[16] bl2_n[16]
+ bl2_n[17] bl2[17] bl2[18] bl2_n[18] bl2_n[19] bl2[19] bl2[20] bl2_n[20]
+ bl2_n[21] bl2[21] bl2[22] bl2_n[22] bl2_n[23] bl2[23] bl2[24] bl2_n[24]
+ bl2_n[25] bl2[25] bl2[26] bl2_n[26] bl2_n[27] bl2[27] bl2[28] bl2_n[28]
+ bl2_n[29] bl2[29] bl2[30] bl2_n[30] bl2_n[31] bl2[31] we_en2 clk2 we2 q2[0]
+ d2[0] q2[1] d2[1] q2[2] d2[2] q2[3] d2[3] mux2[3] mux2[2] mux2[0] mux2[1]
+ q2[4] d2[4] q2[5] d2[5] q2[6] d2[6] q2[7] d2[7]
X$1 vss we1 d1[0] d1[1] vdd d1[2] d1[3] d1[4] d1[5] d1[6] d1[7] clk1 we_en1
+ q1[0] q1[1] q1[2] q1[3] q1[4] q1[5] q1[6] q1[7] bl1[0] bl1_n[0] bl1_n[1]
+ bl1[1] bl1[2] bl1_n[2] bl1_n[3] bl1[3] bl1[4] bl1_n[4] bl1_n[5] bl1[5] bl1[6]
+ bl1_n[6] bl1_n[7] bl1[7] bl1[8] bl1_n[8] bl1_n[9] bl1[9] bl1[10] bl1_n[10]
+ bl1_n[11] bl1[11] bl1[12] bl1_n[12] bl1_n[13] bl1[13] bl1[14] bl1_n[14]
+ bl1_n[15] bl1[15] mux1[0] bl1[16] bl1_n[16] bl1_n[17] bl1[17] bl1[18]
+ bl1_n[18] bl1_n[19] bl1[19] bl1[20] bl1_n[20] bl1_n[21] bl1[21] bl1[22]
+ bl1_n[22] bl1_n[23] bl1[23] bl1[24] bl1_n[24] bl1_n[25] bl1[25] bl1[26]
+ bl1_n[26] bl1_n[27] bl1[27] bl1[28] bl1_n[28] bl1_n[29] bl1[29] bl1[30]
+ bl1_n[30] bl1_n[31] bl1[31] mux1[1] mux1[3] mux1[2]
+ DP8TColumnPeriphery_8B4M_bl1
X$3 vss we2 d2[7] d2[6] vdd d2[5] d2[4] d2[3] d2[2] d2[1] d2[0] clk2 we_en2
+ q2[7] q2[6] q2[5] q2[4] q2[3] q2[2] q2[1] q2[0] bl2[31] bl2_n[31] bl2_n[30]
+ bl2[30] bl2[29] bl2_n[29] bl2_n[28] bl2[28] bl2[27] bl2_n[27] bl2_n[26]
+ bl2[26] bl2[25] bl2_n[25] bl2_n[24] bl2[24] bl2[23] bl2_n[23] bl2_n[22]
+ bl2[22] bl2[21] bl2_n[21] bl2_n[20] bl2[20] bl2[19] bl2_n[19] bl2_n[18]
+ bl2[18] bl2[17] bl2_n[17] bl2_n[16] bl2[16] mux2[0] bl2[15] bl2_n[15]
+ bl2_n[14] bl2[14] bl2[13] bl2_n[13] bl2_n[12] bl2[12] bl2[11] bl2_n[11]
+ bl2_n[10] bl2[10] bl2[9] bl2_n[9] bl2_n[8] bl2[8] bl2[7] bl2_n[7] bl2_n[6]
+ bl2[6] bl2[5] bl2_n[5] bl2_n[4] bl2[4] bl2[3] bl2_n[3] bl2_n[2] bl2[2] bl2[1]
+ bl2_n[1] bl2_n[0] bl2[0] mux2[1] mux2[2] mux2[3] DP8TColumnPeriphery_8B4M_bl2
.ENDS DP8TColumn_128R8B4M

.SUBCKT DP8TClockGenerator_8S1R vss vdd clk decodeclk wl_en precharge_n
+ columnclk we_en
X$1 vdd vss \$7 wl_en buf_x1
X$2 vdd vss clk decodeclk buf_x1
X$3 vss vdd precharge_n \$10 inv_x1
X$4 vdd vss clk columnclk buf_x1
X$5 vss vdd \$7 \$10 clk DP8TNonOverlapClock_8S1R
X$6 vdd vss \$7 we_en buf_x1
.ENDS DP8TClockGenerator_8S1R

.SUBCKT DP8TLatchedDecoder_2A2R vss vdd a[0] a[1] line[0] line[1] line[2]
+ line[3] clk
X$1 vss a[0] \$11 clk vdd DP8TDec_dff_x1
X$2 vss a[1] \$12 clk vdd DP8TDec_dff_x1
X$3 vss vdd \$13 \$11 DP8TDec_inv_x1
X$4 vss vdd \$13 \$16 \$14 DP8TDec_nand2_x0
X$5 vss vdd line[0] \$16 DP8TDec_inv_x2
X$6 vss vdd \$11 \$17 \$14 DP8TDec_nand2_x0
X$7 vss vdd line[1] \$17 DP8TDec_inv_x2
X$8 vss vdd \$13 \$18 \$12 DP8TDec_nand2_x0
X$9 vss vdd \$14 \$12 DP8TDec_inv_x1
X$10 vss vdd line[2] \$18 DP8TDec_inv_x2
X$11 vss vdd \$11 \$19 \$12 DP8TDec_nand2_x0
X$12 vss vdd line[3] \$19 DP8TDec_inv_x2
.ENDS DP8TLatchedDecoder_2A2R

.SUBCKT DP8TRowDecoder_3_4B_wl1 vss vdd a[0] a[1] a[2] a[3] clk a[4] a[5] a[6]
X$2 vss vdd \$8 \$41 \$9 \$28 \$96 \$19 \$39 \$159 \$40 \$208 \$44 \$45 \$278
+ \$322 \$386 \$449 \$508 \$562 \$621 \$665 \$741 \$778 \$837 \$902 clk a[0]
+ a[1] a[2] a[3] a[4] a[5] a[6] DP8TRowPredecoders_3_4B_wl1
.ENDS DP8TRowDecoder_3_4B_wl1

.SUBCKT DP8TRowPredecoders_3_4B_wl2 vss vdd pd[0][0] page[15] pd[0][1] pd[0][2]
+ page[14] pd[0][3] pd[0][4] page[13] pd[0][5] page[12] pd[0][6] pd[0][7]
+ page[11] page[10] page[9] page[8] page[7] page[6] page[5] page[4] page[3]
+ page[2] page[1] page[0] clk a[0] a[1] a[2] a[3] a[4] a[5] a[6]
X$1 vss a[0] \$34 clk vdd DP8TDec_dff_x1
X$2 vss vdd \$27 \$34 DP8TDec_inv_x1
X$3 vdd vss \$27 \$28 \$29 pd[0][0] DP8TDec_and3_x1
X$4 vdd vss \$30 \$31 \$32 \$33 page[15] DP8TDec_and4_x1
X$5 vdd vss \$34 \$28 \$29 pd[0][1] DP8TDec_and3_x1
X$6 vss a[1] \$35 clk vdd DP8TDec_dff_x1
X$7 vdd vss \$27 \$35 \$29 pd[0][2] DP8TDec_and3_x1
X$8 vss vdd \$28 \$35 DP8TDec_inv_x1
X$9 vdd vss \$36 \$31 \$32 \$33 page[14] DP8TDec_and4_x1
X$10 vdd vss \$34 \$35 \$29 pd[0][3] DP8TDec_and3_x1
X$11 vss a[2] \$37 clk vdd DP8TDec_dff_x1
X$12 vdd vss \$27 \$28 \$37 pd[0][4] DP8TDec_and3_x1
X$13 vss vdd \$29 \$37 DP8TDec_inv_x1
X$14 vdd vss \$30 \$38 \$32 \$33 page[13] DP8TDec_and4_x1
X$15 vdd vss \$34 \$28 \$37 pd[0][5] DP8TDec_and3_x1
X$16 vss a[3] \$30 clk vdd DP8TDec_dff_x1
X$17 vdd vss \$36 \$38 \$32 \$33 page[12] DP8TDec_and4_x1
X$18 vss vdd \$36 \$30 DP8TDec_inv_x1
X$19 vdd vss \$27 \$35 \$37 pd[0][6] DP8TDec_and3_x1
X$20 vdd vss \$34 \$35 \$37 pd[0][7] DP8TDec_and3_x1
X$21 vss a[4] \$31 clk vdd DP8TDec_dff_x1
X$23 vss vdd \$38 \$31 DP8TDec_inv_x1
X$24 vdd vss \$30 \$31 \$39 \$33 page[11] DP8TDec_and4_x1
X$26 vss a[5] \$32 clk vdd DP8TDec_dff_x1
X$27 vdd vss \$36 \$31 \$39 \$33 page[10] DP8TDec_and4_x1
X$28 vss vdd \$39 \$32 DP8TDec_inv_x1
X$31 vss a[6] \$33 clk vdd DP8TDec_dff_x1
X$32 vdd vss \$30 \$38 \$39 \$33 page[9] DP8TDec_and4_x1
X$33 vss vdd \$40 \$33 DP8TDec_inv_x1
X$37 vdd vss \$36 \$38 \$39 \$33 page[8] DP8TDec_and4_x1
X$43 vdd vss \$30 \$31 \$32 \$40 page[7] DP8TDec_and4_x1
X$49 vdd vss \$36 \$31 \$32 \$40 page[6] DP8TDec_and4_x1
X$55 vdd vss \$30 \$38 \$32 \$40 page[5] DP8TDec_and4_x1
X$59 vdd vss \$36 \$38 \$32 \$40 page[4] DP8TDec_and4_x1
X$67 vdd vss \$30 \$31 \$39 \$40 page[3] DP8TDec_and4_x1
X$71 vdd vss \$36 \$31 \$39 \$40 page[2] DP8TDec_and4_x1
X$77 vdd vss \$30 \$38 \$39 \$40 page[1] DP8TDec_and4_x1
X$83 vdd vss \$36 \$38 \$39 \$40 page[0] DP8TDec_and4_x1
.ENDS DP8TRowPredecoders_3_4B_wl2

.SUBCKT DP8TColumnPeriphery_8B4M_bl2 vss we d[0] d[1] vdd d[2] d[3] d[4] d[5]
+ d[6] d[7] clk we_en q[0] q[1] q[2] q[3] q[4] q[5] q[6] q[7] bl[0] bl_n[0]
+ bl_n[1] bl[1] bl[2] bl_n[2] bl_n[3] bl[3] bl[4] bl_n[4] bl_n[5] bl[5] bl[6]
+ bl_n[6] bl_n[7] bl[7] bl[8] bl_n[8] bl_n[9] bl[9] bl[10] bl_n[10] bl_n[11]
+ bl[11] bl[12] bl_n[12] bl_n[13] bl[13] bl[14] bl_n[14] bl_n[15] bl[15] mux[0]
+ bl[16] bl_n[16] bl_n[17] bl[17] bl[18] bl_n[18] bl_n[19] bl[19] bl[20]
+ bl_n[20] bl_n[21] bl[21] bl[22] bl_n[22] bl_n[23] bl[23] bl[24] bl_n[24]
+ bl_n[25] bl[25] bl[26] bl_n[26] bl_n[27] bl[27] bl[28] bl_n[28] bl_n[29]
+ bl[29] bl[30] bl_n[30] bl_n[31] bl[31] mux[1] mux[2] mux[3]
X$1 \$101 bl[4] bl_n[4] \$99 bl_n[5] bl[5] bl[6] bl_n[6] bl_n[7] bl[7] mux[0]
+ vss mux[1] mux[2] mux[3] DP8TColMux_4C_bl2
X$2 \$93 bl[0] bl_n[0] \$97 bl_n[1] bl[1] bl[2] bl_n[2] bl_n[3] bl[3] mux[0]
+ vss mux[1] mux[2] mux[3] DP8TColMux_4C_bl2
X$8 \$106 bl[8] bl_n[8] \$107 bl_n[9] bl[9] bl[10] bl_n[10] bl_n[11] bl[11]
+ mux[0] vss mux[1] mux[2] mux[3] DP8TColMux_4C_bl2
X$13 \$104 bl[12] bl_n[12] \$105 bl_n[13] bl[13] bl[14] bl_n[14] bl_n[15]
+ bl[15] mux[0] vss mux[1] mux[2] mux[3] DP8TColMux_4C_bl2
X$18 \$102 bl[16] bl_n[16] \$103 bl_n[17] bl[17] bl[18] bl_n[18] bl_n[19]
+ bl[19] mux[0] vss mux[1] mux[2] mux[3] DP8TColMux_4C_bl2
X$23 \$100 bl[20] bl_n[20] \$98 bl_n[21] bl[21] bl[22] bl_n[22] bl_n[23] bl[23]
+ mux[0] vss mux[1] mux[2] mux[3] DP8TColMux_4C_bl2
X$28 \$95 bl[24] bl_n[24] \$96 bl_n[25] bl[25] bl[26] bl_n[26] bl_n[27] bl[27]
+ mux[0] vss mux[1] mux[2] mux[3] DP8TColMux_4C_bl2
X$33 \$94 bl[28] bl_n[28] \$92 bl_n[29] bl[29] bl[30] bl_n[30] bl_n[31] bl[31]
+ mux[0] vss mux[1] mux[2] mux[3] DP8TColMux_4C_bl2
X$41 \$93 vss \$97 vdd q[0] d[0] \$12 \$16 DP8TReadWrite_4M
X$42 \$101 vss \$99 vdd q[1] d[1] \$12 \$16 DP8TReadWrite_4M
X$43 \$106 vss \$107 vdd q[2] d[2] \$12 \$16 DP8TReadWrite_4M
X$44 \$104 vss \$105 vdd q[3] d[3] \$12 \$16 DP8TReadWrite_4M
X$45 \$102 vss \$103 vdd q[4] d[4] \$12 \$16 DP8TReadWrite_4M
X$46 \$100 vss \$98 vdd q[5] d[5] \$12 \$16 DP8TReadWrite_4M
X$47 \$95 vss \$96 vdd q[6] d[6] \$12 \$16 DP8TReadWrite_4M
X$48 clk we we_en \$16 vss vdd \$12 DP8TClockWE
X$49 \$94 vss \$92 vdd q[7] d[7] \$12 \$16 DP8TReadWrite_4M
.ENDS DP8TColumnPeriphery_8B4M_bl2

.SUBCKT DP8TColumnPeriphery_8B4M_bl1 vss we d[0] d[1] vdd d[2] d[3] d[4] d[5]
+ d[6] d[7] clk we_en q[0] q[1] q[2] q[3] q[4] q[5] q[6] q[7] bl[0] bl_n[0]
+ bl_n[1] bl[1] bl[2] bl_n[2] bl_n[3] bl[3] bl[4] bl_n[4] bl_n[5] bl[5] bl[6]
+ bl_n[6] bl_n[7] bl[7] bl[8] bl_n[8] bl_n[9] bl[9] bl[10] bl_n[10] bl_n[11]
+ bl[11] bl[12] bl_n[12] bl_n[13] bl[13] bl[14] bl_n[14] bl_n[15] bl[15] mux[0]
+ bl[16] bl_n[16] bl_n[17] bl[17] bl[18] bl_n[18] bl_n[19] bl[19] bl[20]
+ bl_n[20] bl_n[21] bl[21] bl[22] bl_n[22] bl_n[23] bl[23] bl[24] bl_n[24]
+ bl_n[25] bl[25] bl[26] bl_n[26] bl_n[27] bl[27] bl[28] bl_n[28] bl_n[29]
+ bl[29] bl[30] bl_n[30] bl_n[31] bl[31] mux[1] mux[3] mux[2]
X$1 \$101 bl[4] bl_n[4] \$99 bl_n[5] bl[5] bl[6] bl_n[6] bl_n[7] bl[7] mux[0]
+ vss mux[1] mux[2] mux[3] DP8TColMux_4C_bl1
X$2 \$93 bl[0] bl_n[0] \$97 bl_n[1] bl[1] bl[2] bl_n[2] bl_n[3] bl[3] mux[0]
+ vss mux[1] mux[2] mux[3] DP8TColMux_4C_bl1
X$8 \$106 bl[8] bl_n[8] \$107 bl_n[9] bl[9] bl[10] bl_n[10] bl_n[11] bl[11]
+ mux[0] vss mux[1] mux[2] mux[3] DP8TColMux_4C_bl1
X$13 \$104 bl[12] bl_n[12] \$105 bl_n[13] bl[13] bl[14] bl_n[14] bl_n[15]
+ bl[15] mux[0] vss mux[1] mux[2] mux[3] DP8TColMux_4C_bl1
X$18 \$102 bl[16] bl_n[16] \$103 bl_n[17] bl[17] bl[18] bl_n[18] bl_n[19]
+ bl[19] mux[0] vss mux[1] mux[2] mux[3] DP8TColMux_4C_bl1
X$23 \$100 bl[20] bl_n[20] \$98 bl_n[21] bl[21] bl[22] bl_n[22] bl_n[23] bl[23]
+ mux[0] vss mux[1] mux[2] mux[3] DP8TColMux_4C_bl1
X$28 \$95 bl[24] bl_n[24] \$96 bl_n[25] bl[25] bl[26] bl_n[26] bl_n[27] bl[27]
+ mux[0] vss mux[1] mux[2] mux[3] DP8TColMux_4C_bl1
X$33 \$94 bl[28] bl_n[28] \$92 bl_n[29] bl[29] bl[30] bl_n[30] bl_n[31] bl[31]
+ mux[0] vss mux[1] mux[2] mux[3] DP8TColMux_4C_bl1
X$41 \$93 vss \$97 vdd q[0] d[0] \$12 \$16 DP8TReadWrite_4M
X$42 \$101 vss \$99 vdd q[1] d[1] \$12 \$16 DP8TReadWrite_4M
X$43 \$106 vss \$107 vdd q[2] d[2] \$12 \$16 DP8TReadWrite_4M
X$44 \$104 vss \$105 vdd q[3] d[3] \$12 \$16 DP8TReadWrite_4M
X$45 \$102 vss \$103 vdd q[4] d[4] \$12 \$16 DP8TReadWrite_4M
X$46 \$100 vss \$98 vdd q[5] d[5] \$12 \$16 DP8TReadWrite_4M
X$47 \$95 vss \$96 vdd q[6] d[6] \$12 \$16 DP8TReadWrite_4M
X$48 clk we we_en \$16 vss vdd \$12 DP8TClockWE
X$49 \$94 vss \$92 vdd q[7] d[7] \$12 \$16 DP8TReadWrite_4M
.ENDS DP8TColumnPeriphery_8B4M_bl1

.SUBCKT DP8TNonOverlapClock_8S1R vss vdd firststage[7] secondstage[7] clk
X$1 vss vdd secondstage[8] secondstage[7] inv_x0
X$2 vss vdd secondstage[7] secondstage[6] inv_x0
X$3 vss vdd secondstage[6] secondstage[5] inv_x0
X$4 vss vdd secondstage[5] secondstage[4] inv_x0
X$5 vss vdd secondstage[4] secondstage[3] inv_x0
X$6 vss vdd secondstage[3] secondstage[2] inv_x0
X$7 vss vdd secondstage[2] secondstage[1] inv_x0
X$8 vss vdd secondstage[1] secondstage[0] inv_x0
X$9 vss vdd \$23 secondstage[0] firststage[8] nand2_x0
X$10 vss vdd \$23 clk inv_x0
X$11 vss vdd clk firststage[0] secondstage[8] nand2_x0
X$12 vss vdd firststage[1] firststage[0] inv_x0
X$13 vss vdd firststage[2] firststage[1] inv_x0
X$14 vss vdd firststage[3] firststage[2] inv_x0
X$15 vss vdd firststage[4] firststage[3] inv_x0
X$16 vss vdd firststage[5] firststage[4] inv_x0
X$17 vss vdd firststage[6] firststage[5] inv_x0
X$18 vss vdd firststage[7] firststage[6] inv_x0
X$19 vss vdd firststage[8] firststage[7] inv_x0
.ENDS DP8TNonOverlapClock_8S1R

.SUBCKT inv_x1 vss vdd nq i
M$1 vss i nq vss sg13_lv_nmos L=0.13u W=1.46u AS=0.4964p AD=0.4964p PS=3.6u
+ PD=3.6u
M$2 vdd i nq vdd sg13_lv_pmos L=0.13u W=1.45u AS=0.493p AD=0.493p PS=3.58u
+ PD=3.58u
.ENDS inv_x1

.SUBCKT buf_x1 vdd vss i q
M$1 \$1 i vss vss sg13_lv_nmos L=0.13u W=0.78u AS=0.2652p AD=0.2092p PS=2.24u
+ PD=1.48u
M$2 vss \$1 q vss sg13_lv_nmos L=0.13u W=1.07u AS=0.2092p AD=0.3638p PS=1.48u
+ PD=2.82u
M$3 vdd i \$1 vdd sg13_lv_pmos L=0.13u W=0.78u AS=0.2075p AD=0.2652p PS=1.47u
+ PD=2.24u
M$4 vdd \$1 q vdd sg13_lv_pmos L=0.13u W=1.06u AS=0.2075p AD=0.3604p PS=1.47u
+ PD=2.8u
.ENDS buf_x1

.SUBCKT DP8TDec_inv_x2 vss vdd nq i
M$1 vss i nq vss sg13_lv_nmos L=0.13u W=5.6u AS=1.484p AD=1.484p PS=9.46u
+ PD=9.46u
M$3 vdd i nq vdd sg13_lv_pmos L=0.13u W=8.8u AS=2.332p AD=2.332p PS=14.26u
+ PD=14.26u
.ENDS DP8TDec_inv_x2

.SUBCKT DP8TDec_nand2_x0 vss vdd i0 nq i1
M$1 vss i0 \$6 vss sg13_lv_nmos L=0.13u W=0.78u AS=0.2652p AD=0.1482p PS=2.24u
+ PD=1.16u
M$2 \$6 i1 nq vss sg13_lv_nmos L=0.13u W=0.78u AS=0.1482p AD=0.312p PS=1.16u
+ PD=2.36u
M$3 vdd i0 nq vdd sg13_lv_pmos L=0.13u W=1.2u AS=0.408p AD=0.228p PS=3.08u
+ PD=1.58u
M$4 nq i1 vdd vdd sg13_lv_pmos L=0.13u W=1.2u AS=0.228p AD=0.48p PS=1.58u
+ PD=3.2u
.ENDS DP8TDec_nand2_x0

.SUBCKT DP8TRowPredecoders_3_4B_wl1 vss vdd pd[0][0] page[0] pd[0][1] pd[0][2]
+ page[1] pd[0][3] pd[0][4] page[2] pd[0][5] page[3] pd[0][6] pd[0][7] page[4]
+ page[5] page[6] page[7] page[8] page[9] page[10] page[11] page[12] page[13]
+ page[14] page[15] clk a[0] a[1] a[2] a[3] a[4] a[5] a[6]
X$1 vss a[0] \$34 clk vdd DP8TDec_dff_x1
X$2 vss vdd \$27 \$34 DP8TDec_inv_x1
X$3 vdd vss \$27 \$28 \$29 pd[0][0] DP8TDec_and3_x1
X$4 vdd vss \$30 \$31 \$32 \$33 page[0] DP8TDec_and4_x1
X$5 vdd vss \$34 \$28 \$29 pd[0][1] DP8TDec_and3_x1
X$6 vss a[1] \$35 clk vdd DP8TDec_dff_x1
X$7 vdd vss \$27 \$35 \$29 pd[0][2] DP8TDec_and3_x1
X$8 vss vdd \$28 \$35 DP8TDec_inv_x1
X$9 vdd vss \$36 \$31 \$32 \$33 page[1] DP8TDec_and4_x1
X$10 vdd vss \$34 \$35 \$29 pd[0][3] DP8TDec_and3_x1
X$11 vss a[2] \$37 clk vdd DP8TDec_dff_x1
X$12 vdd vss \$27 \$28 \$37 pd[0][4] DP8TDec_and3_x1
X$13 vss vdd \$29 \$37 DP8TDec_inv_x1
X$14 vdd vss \$30 \$38 \$32 \$33 page[2] DP8TDec_and4_x1
X$15 vdd vss \$34 \$28 \$37 pd[0][5] DP8TDec_and3_x1
X$16 vss a[3] \$36 clk vdd DP8TDec_dff_x1
X$17 vdd vss \$36 \$38 \$32 \$33 page[3] DP8TDec_and4_x1
X$18 vss vdd \$30 \$36 DP8TDec_inv_x1
X$19 vdd vss \$27 \$35 \$37 pd[0][6] DP8TDec_and3_x1
X$20 vdd vss \$34 \$35 \$37 pd[0][7] DP8TDec_and3_x1
X$21 vss a[4] \$38 clk vdd DP8TDec_dff_x1
X$23 vss vdd \$31 \$38 DP8TDec_inv_x1
X$24 vdd vss \$30 \$31 \$39 \$33 page[4] DP8TDec_and4_x1
X$26 vss a[5] \$39 clk vdd DP8TDec_dff_x1
X$27 vdd vss \$36 \$31 \$39 \$33 page[5] DP8TDec_and4_x1
X$28 vss vdd \$32 \$39 DP8TDec_inv_x1
X$31 vss a[6] \$48 clk vdd DP8TDec_dff_x1
X$32 vdd vss \$30 \$38 \$39 \$33 page[6] DP8TDec_and4_x1
X$33 vss vdd \$33 \$48 DP8TDec_inv_x1
X$37 vdd vss \$36 \$38 \$39 \$33 page[7] DP8TDec_and4_x1
X$43 vdd vss \$30 \$31 \$32 \$48 page[8] DP8TDec_and4_x1
X$49 vdd vss \$36 \$31 \$32 \$48 page[9] DP8TDec_and4_x1
X$55 vdd vss \$30 \$38 \$32 \$48 page[10] DP8TDec_and4_x1
X$59 vdd vss \$36 \$38 \$32 \$48 page[11] DP8TDec_and4_x1
X$67 vdd vss \$30 \$31 \$39 \$48 page[12] DP8TDec_and4_x1
X$71 vdd vss \$36 \$31 \$39 \$48 page[13] DP8TDec_and4_x1
X$77 vdd vss \$30 \$38 \$39 \$48 page[14] DP8TDec_and4_x1
X$83 vdd vss \$36 \$38 \$39 \$48 page[15] DP8TDec_and4_x1
.ENDS DP8TRowPredecoders_3_4B_wl1

.SUBCKT DP8TColMux_4C_bl2 muxbl bl[0] bl_n[0] muxbl_n bl_n[1] bl[1] bl[2]
+ bl_n[2] bl_n[3] bl[3] mux[0] vss mux[1] mux[2] mux[3]
M$1 bl[1] mux[1] muxbl vss sg13_lv_nmos L=0.13u W=3.5u AS=1.19p AD=0.665p
+ PS=7.68u PD=3.88u
M$2 muxbl mux[2] bl[2] vss sg13_lv_nmos L=0.13u W=3.5u AS=0.665p AD=1.19p
+ PS=3.88u PD=7.68u
M$3 bl[3] mux[3] muxbl vss sg13_lv_nmos L=0.13u W=3.5u AS=1.19p AD=1.19p
+ PS=7.68u PD=7.68u
M$4 bl_n[0] mux[0] muxbl_n vss sg13_lv_nmos L=0.13u W=3.5u AS=1.19p AD=0.665p
+ PS=7.68u PD=3.88u
M$5 muxbl_n mux[1] bl_n[1] vss sg13_lv_nmos L=0.13u W=3.5u AS=0.665p AD=1.19p
+ PS=3.88u PD=7.68u
M$6 bl_n[2] mux[2] muxbl_n vss sg13_lv_nmos L=0.13u W=3.5u AS=1.19p AD=0.665p
+ PS=7.68u PD=3.88u
M$7 muxbl_n mux[3] bl_n[3] vss sg13_lv_nmos L=0.13u W=3.5u AS=0.665p AD=1.19p
+ PS=3.88u PD=7.68u
M$8 muxbl mux[0] bl[0] vss sg13_lv_nmos L=0.13u W=3.5u AS=1.19p AD=1.19p
+ PS=7.68u PD=7.68u
.ENDS DP8TColMux_4C_bl2

.SUBCKT DP8TColMux_4C_bl1 muxbl bl[0] bl_n[0] muxbl_n bl_n[1] bl[1] bl[2]
+ bl_n[2] bl_n[3] bl[3] mux[0] vss mux[1] mux[2] mux[3]
M$1 bl[1] mux[1] muxbl vss sg13_lv_nmos L=0.13u W=3.5u AS=1.19p AD=0.665p
+ PS=7.68u PD=3.88u
M$2 muxbl mux[2] bl[2] vss sg13_lv_nmos L=0.13u W=3.5u AS=0.665p AD=1.19p
+ PS=3.88u PD=7.68u
M$3 bl[3] mux[3] muxbl vss sg13_lv_nmos L=0.13u W=3.5u AS=1.19p AD=1.19p
+ PS=7.68u PD=7.68u
M$4 bl_n[0] mux[0] muxbl_n vss sg13_lv_nmos L=0.13u W=3.5u AS=1.19p AD=0.665p
+ PS=7.68u PD=3.88u
M$5 muxbl_n mux[1] bl_n[1] vss sg13_lv_nmos L=0.13u W=3.5u AS=0.665p AD=1.19p
+ PS=3.88u PD=7.68u
M$6 bl_n[2] mux[2] muxbl_n vss sg13_lv_nmos L=0.13u W=3.5u AS=1.19p AD=0.665p
+ PS=7.68u PD=3.88u
M$7 muxbl_n mux[3] bl_n[3] vss sg13_lv_nmos L=0.13u W=3.5u AS=0.665p AD=1.19p
+ PS=3.88u PD=7.68u
M$8 muxbl mux[0] bl[0] vss sg13_lv_nmos L=0.13u W=3.5u AS=1.19p AD=1.19p
+ PS=7.68u PD=7.68u
.ENDS DP8TColMux_4C_bl1

.SUBCKT DP8TReadWrite_4M bl vss bl_n vdd q d clk we_n
X$1 q vdd vss bl_n bl nsnrlatch_x1
X$2 vss vdd \$5 \$16 we_n nor2_x0
X$3 vss vdd \$16 \$11 inv_x0
X$4 vss d \$11 clk vdd dff_x1
X$5 vss vdd \$3 \$11 we_n nor2_x0
M$1 bl \$3 vss vss sg13_lv_nmos L=0.13u W=1.9u AS=0.5074p AD=0.361p PS=4.48u
+ PD=2.28u
M$2 vss \$5 bl_n vss sg13_lv_nmos L=0.13u W=1.9u AS=0.361p AD=0.5074p PS=2.28u
+ PD=4.48u
.ENDS DP8TReadWrite_4M

.SUBCKT DP8TClockWE clkup we we_en we_n vss vdd clkdown
X$1 vdd vss clkup clkdown buf_x2
X$2 vss we \$9 clkdown vdd dff_x1
X$3 vss vdd \$9 we_n we_en nand2_x0
.ENDS DP8TClockWE

.SUBCKT DP8TDec_and4_x1 vdd vss i0 i1 i2 i3 q
M$1 \$1 i0 \$11 vss sg13_lv_nmos L=0.13u W=0.78u AS=0.2652p AD=0.1482p PS=2.24u
+ PD=1.16u
M$2 \$11 i1 \$10 vss sg13_lv_nmos L=0.13u W=0.78u AS=0.1482p AD=0.1482p
+ PS=1.16u PD=1.16u
M$3 \$10 i2 \$9 vss sg13_lv_nmos L=0.13u W=0.78u AS=0.1482p AD=0.1482p PS=1.16u
+ PD=1.16u
M$4 \$9 i3 vss vss sg13_lv_nmos L=0.13u W=0.78u AS=0.1482p AD=0.5033p PS=1.16u
+ PD=3.21u
M$5 vss \$1 q vss sg13_lv_nmos L=0.13u W=2.8u AS=0.5033p AD=1.036p PS=3.21u
+ PD=6.34u
M$6 vdd i0 \$1 vdd sg13_lv_pmos L=0.13u W=1.2u AS=0.408p AD=0.228p PS=3.08u
+ PD=1.58u
M$7 \$1 i1 vdd vdd sg13_lv_pmos L=0.13u W=1.2u AS=0.228p AD=0.228p PS=1.58u
+ PD=1.58u
M$8 vdd i2 \$1 vdd sg13_lv_pmos L=0.13u W=1.2u AS=0.228p AD=0.228p PS=1.58u
+ PD=1.58u
M$9 vdd i3 \$1 vdd sg13_lv_pmos L=0.13u W=1.2u AS=0.79p AD=0.228p PS=4.81u
+ PD=1.58u
M$10 vdd \$1 q vdd sg13_lv_pmos L=0.13u W=4.4u AS=0.79p AD=1.628p PS=4.81u
+ PD=9.54u
.ENDS DP8TDec_and4_x1

.SUBCKT DP8TDec_and3_x1 vdd vss i0 i1 i2 q
M$1 \$1 i0 \$9 vss sg13_lv_nmos L=0.13u W=0.78u AS=0.2652p AD=0.1482p PS=2.24u
+ PD=1.16u
M$2 \$9 i1 \$8 vss sg13_lv_nmos L=0.13u W=0.78u AS=0.1482p AD=0.1482p PS=1.16u
+ PD=1.16u
M$3 \$8 i2 vss vss sg13_lv_nmos L=0.13u W=0.78u AS=0.1482p AD=0.5033p PS=1.16u
+ PD=3.21u
M$4 vss \$1 q vss sg13_lv_nmos L=0.13u W=2.8u AS=0.5033p AD=1.036p PS=3.21u
+ PD=6.34u
M$5 \$1 i0 vdd vdd sg13_lv_pmos L=0.13u W=1.2u AS=0.408p AD=0.228p PS=3.08u
+ PD=1.58u
M$6 vdd i1 \$1 vdd sg13_lv_pmos L=0.13u W=1.2u AS=0.228p AD=0.228p PS=1.58u
+ PD=1.58u
M$7 vdd i2 \$1 vdd sg13_lv_pmos L=0.13u W=1.2u AS=0.79p AD=0.228p PS=4.81u
+ PD=1.58u
M$8 vdd \$1 q vdd sg13_lv_pmos L=0.13u W=4.4u AS=0.79p AD=1.628p PS=4.81u
+ PD=9.54u
.ENDS DP8TDec_and3_x1

.SUBCKT DP8TDec_inv_x1 vss vdd nq i
M$1 vss i nq vss sg13_lv_nmos L=0.13u W=2.8u AS=0.952p AD=0.952p PS=6.28u
+ PD=6.28u
M$2 vdd i nq vdd sg13_lv_pmos L=0.13u W=4.4u AS=1.496p AD=1.496p PS=9.48u
+ PD=9.48u
.ENDS DP8TDec_inv_x1

.SUBCKT DP8TDec_dff_x1 vss i q clk vdd
M$1 \$4 i vss vss sg13_lv_nmos L=0.13u W=0.78u AS=0.2652p AD=0.1482p PS=2.24u
+ PD=1.16u
M$2 vss \$4 \$11 vss sg13_lv_nmos L=0.13u W=0.78u AS=0.1482p AD=0.1482p
+ PS=1.16u PD=1.16u
M$3 \$11 \$2 \$6 vss sg13_lv_nmos L=0.13u W=0.78u AS=0.1482p AD=0.1482p
+ PS=1.16u PD=1.16u
M$4 \$6 \$3 \$12 vss sg13_lv_nmos L=0.13u W=0.78u AS=0.1482p AD=0.1482p
+ PS=1.16u PD=1.16u
M$5 \$12 \$7 vss vss sg13_lv_nmos L=0.13u W=0.78u AS=0.1482p AD=0.1638p
+ PS=1.16u PD=1.2u
M$6 vss \$6 \$7 vss sg13_lv_nmos L=0.13u W=0.78u AS=0.1638p AD=0.2496p PS=1.2u
+ PD=1.42u
M$7 \$7 \$3 \$8 vss sg13_lv_nmos L=0.13u W=0.78u AS=0.2496p AD=0.1482p PS=1.42u
+ PD=1.16u
M$8 \$8 \$2 \$10 vss sg13_lv_nmos L=0.13u W=0.78u AS=0.1482p AD=0.1482p
+ PS=1.16u PD=1.16u
M$9 \$10 q vss vss sg13_lv_nmos L=0.13u W=0.78u AS=0.1482p AD=0.7217p PS=1.16u
+ PD=2.88u
M$10 vss \$8 q vss sg13_lv_nmos L=0.13u W=2.17u AS=0.7217p AD=0.7378p PS=2.88u
+ PD=5.02u
M$11 \$2 clk vss vss sg13_lv_nmos L=0.13u W=0.78u AS=0.2652p AD=0.1716p
+ PS=2.24u PD=1.22u
M$12 vss \$2 \$3 vss sg13_lv_nmos L=0.13u W=0.78u AS=0.1716p AD=0.2652p
+ PS=1.22u PD=2.24u
M$13 \$2 clk vdd vdd sg13_lv_pmos L=0.13u W=1.2u AS=0.408p AD=0.264p PS=3.08u
+ PD=1.64u
M$14 vdd \$2 \$3 vdd sg13_lv_pmos L=0.13u W=1.2u AS=0.264p AD=0.408p PS=1.64u
+ PD=3.08u
M$15 \$4 i vdd vdd sg13_lv_pmos L=0.13u W=1.2u AS=0.408p AD=0.228p PS=3.08u
+ PD=1.58u
M$16 vdd \$4 \$15 vdd sg13_lv_pmos L=0.13u W=1.2u AS=0.228p AD=0.228p PS=1.58u
+ PD=1.58u
M$17 \$15 \$3 \$6 vdd sg13_lv_pmos L=0.13u W=1.2u AS=0.228p AD=0.228p PS=1.58u
+ PD=1.58u
M$18 \$6 \$2 \$16 vdd sg13_lv_pmos L=0.13u W=1.2u AS=0.228p AD=0.228p PS=1.58u
+ PD=1.58u
M$19 \$16 \$7 vdd vdd sg13_lv_pmos L=0.13u W=1.2u AS=0.228p AD=0.252p PS=1.58u
+ PD=1.62u
M$20 vdd \$6 \$7 vdd sg13_lv_pmos L=0.13u W=1.2u AS=0.252p AD=0.384p PS=1.62u
+ PD=1.84u
M$21 \$7 \$2 \$8 vdd sg13_lv_pmos L=0.13u W=1.2u AS=0.384p AD=0.228p PS=1.84u
+ PD=1.58u
M$22 \$8 \$3 \$17 vdd sg13_lv_pmos L=0.13u W=1.2u AS=0.228p AD=0.228p PS=1.58u
+ PD=1.58u
M$23 vdd q \$17 vdd sg13_lv_pmos L=0.13u W=1.2u AS=1.2484p AD=0.228p PS=4.48u
+ PD=1.58u
M$24 vdd \$8 q vdd sg13_lv_pmos L=0.13u W=3.77u AS=1.2484p AD=1.2818p PS=4.48u
+ PD=8.22u
.ENDS DP8TDec_dff_x1

.SUBCKT nor2_x0 vss vdd nq i0 i1
M$1 vss i0 nq vss sg13_lv_nmos L=0.13u W=0.78u AS=0.2652p AD=0.1482p PS=2.24u
+ PD=1.16u
M$2 nq i1 vss vss sg13_lv_nmos L=0.13u W=0.78u AS=0.1482p AD=0.2808p PS=1.16u
+ PD=2.28u
M$3 vdd i0 \$6 vdd sg13_lv_pmos L=0.13u W=0.78u AS=0.2652p AD=0.1482p PS=2.24u
+ PD=1.16u
M$4 \$6 i1 nq vdd sg13_lv_pmos L=0.13u W=0.78u AS=0.1482p AD=0.2808p PS=1.16u
+ PD=2.28u
.ENDS nor2_x0

.SUBCKT nsnrlatch_x1 q vdd vss nset nrst
M$1 q nset \$8 vss sg13_lv_nmos L=0.13u W=1.31u AS=0.4454p AD=0.2489p PS=3.3u
+ PD=1.69u
M$2 \$8 nq vss vss sg13_lv_nmos L=0.13u W=1.31u AS=0.2489p AD=0.2489p PS=1.69u
+ PD=1.69u
M$3 vss q \$7 vss sg13_lv_nmos L=0.13u W=1.31u AS=0.2489p AD=0.262p PS=1.69u
+ PD=1.71u
M$4 \$7 nrst nq vss sg13_lv_nmos L=0.13u W=1.31u AS=0.262p AD=0.4454p PS=1.71u
+ PD=3.3u
M$5 vdd nset q vdd sg13_lv_pmos L=0.13u W=1.3u AS=0.442p AD=0.247p PS=3.28u
+ PD=1.68u
M$6 q nq vdd vdd sg13_lv_pmos L=0.13u W=1.3u AS=0.247p AD=0.247p PS=1.68u
+ PD=1.68u
M$7 vdd q nq vdd sg13_lv_pmos L=0.13u W=1.3u AS=0.247p AD=0.26p PS=1.68u PD=1.7u
M$8 nq nrst vdd vdd sg13_lv_pmos L=0.13u W=1.3u AS=0.26p AD=0.442p PS=1.7u
+ PD=3.28u
.ENDS nsnrlatch_x1

.SUBCKT dff_x1 vss i q clk vdd
M$1 \$4 i vss vss sg13_lv_nmos L=0.13u W=0.78u AS=0.2652p AD=0.1482p PS=2.24u
+ PD=1.16u
M$2 vss \$4 \$12 vss sg13_lv_nmos L=0.13u W=0.78u AS=0.1482p AD=0.1482p
+ PS=1.16u PD=1.16u
M$3 \$12 \$2 \$6 vss sg13_lv_nmos L=0.13u W=0.78u AS=0.1482p AD=0.1482p
+ PS=1.16u PD=1.16u
M$4 \$6 \$3 \$11 vss sg13_lv_nmos L=0.13u W=0.78u AS=0.1482p AD=0.1482p
+ PS=1.16u PD=1.16u
M$5 \$11 \$7 vss vss sg13_lv_nmos L=0.13u W=0.78u AS=0.1482p AD=0.1482p
+ PS=1.16u PD=1.16u
M$6 vss \$6 \$7 vss sg13_lv_nmos L=0.13u W=0.78u AS=0.1482p AD=0.2028p PS=1.16u
+ PD=1.3u
M$7 \$7 \$3 \$8 vss sg13_lv_nmos L=0.13u W=0.78u AS=0.2028p AD=0.1482p PS=1.3u
+ PD=1.16u
M$8 \$8 \$2 \$10 vss sg13_lv_nmos L=0.13u W=0.78u AS=0.1482p AD=0.1482p
+ PS=1.16u PD=1.16u
M$9 \$10 q vss vss sg13_lv_nmos L=0.13u W=0.78u AS=0.1482p AD=0.2265p PS=1.16u
+ PD=1.38u
M$10 vss \$8 q vss sg13_lv_nmos L=0.13u W=0.83u AS=0.2265p AD=0.2822p PS=1.38u
+ PD=2.34u
M$11 \$2 clk vss vss sg13_lv_nmos L=0.13u W=0.78u AS=0.2652p AD=0.156p PS=2.24u
+ PD=1.18u
M$12 vss \$2 \$3 vss sg13_lv_nmos L=0.13u W=0.78u AS=0.156p AD=0.2652p PS=1.18u
+ PD=2.24u
M$13 \$2 clk vdd vdd sg13_lv_pmos L=0.13u W=0.78u AS=0.2652p AD=0.156p PS=2.24u
+ PD=1.18u
M$14 vdd \$2 \$3 vdd sg13_lv_pmos L=0.13u W=0.78u AS=0.156p AD=0.2652p PS=1.18u
+ PD=2.24u
M$15 \$4 i vdd vdd sg13_lv_pmos L=0.13u W=0.78u AS=0.2652p AD=0.1482p PS=2.24u
+ PD=1.16u
M$16 vdd \$4 \$15 vdd sg13_lv_pmos L=0.13u W=0.78u AS=0.1482p AD=0.1482p
+ PS=1.16u PD=1.16u
M$17 \$15 \$3 \$6 vdd sg13_lv_pmos L=0.13u W=0.78u AS=0.1482p AD=0.1482p
+ PS=1.16u PD=1.16u
M$18 \$6 \$2 \$16 vdd sg13_lv_pmos L=0.13u W=0.78u AS=0.1482p AD=0.1482p
+ PS=1.16u PD=1.16u
M$19 \$16 \$7 vdd vdd sg13_lv_pmos L=0.13u W=0.78u AS=0.1482p AD=0.1482p
+ PS=1.16u PD=1.16u
M$20 vdd \$6 \$7 vdd sg13_lv_pmos L=0.13u W=0.78u AS=0.1482p AD=0.2028p
+ PS=1.16u PD=1.3u
M$21 \$7 \$2 \$8 vdd sg13_lv_pmos L=0.13u W=0.78u AS=0.2028p AD=0.1482p PS=1.3u
+ PD=1.16u
M$22 \$8 \$3 \$17 vdd sg13_lv_pmos L=0.13u W=0.78u AS=0.1482p AD=0.1482p
+ PS=1.16u PD=1.16u
M$23 vdd q \$17 vdd sg13_lv_pmos L=0.13u W=0.78u AS=0.2241p AD=0.1482p PS=1.37u
+ PD=1.16u
M$24 vdd \$8 q vdd sg13_lv_pmos L=0.13u W=0.82u AS=0.2241p AD=0.2788p PS=1.37u
+ PD=2.32u
.ENDS dff_x1

.SUBCKT buf_x2 vdd vss i q
M$1 \$1 i vss vss sg13_lv_nmos L=0.13u W=0.78u AS=0.2652p AD=0.2092p PS=2.24u
+ PD=1.48u
M$2 vss \$1 q vss sg13_lv_nmos L=0.13u W=2.14u AS=0.4125p AD=0.5671p PS=2.93u
+ PD=4.27u
M$4 vdd i \$1 vdd sg13_lv_pmos L=0.13u W=0.78u AS=0.2075p AD=0.2652p PS=1.47u
+ PD=2.24u
M$5 vdd \$1 q vdd sg13_lv_pmos L=0.13u W=2.12u AS=0.4089p AD=0.5618p PS=2.91u
+ PD=4.24u
.ENDS buf_x2

.SUBCKT nand2_x0 vss vdd i0 nq i1
M$1 vss i0 \$6 vss sg13_lv_nmos L=0.13u W=0.78u AS=0.2652p AD=0.1482p PS=2.24u
+ PD=1.16u
M$2 \$6 i1 nq vss sg13_lv_nmos L=0.13u W=0.78u AS=0.1482p AD=0.2808p PS=1.16u
+ PD=2.28u
M$3 vdd i0 nq vdd sg13_lv_pmos L=0.13u W=0.78u AS=0.2652p AD=0.1482p PS=2.24u
+ PD=1.16u
M$4 nq i1 vdd vdd sg13_lv_pmos L=0.13u W=0.78u AS=0.1482p AD=0.2808p PS=1.16u
+ PD=2.28u
.ENDS nand2_x0

.SUBCKT inv_x0 vss vdd nq i
M$1 vss i nq vss sg13_lv_nmos L=0.13u W=0.78u AS=0.2652p AD=0.2652p PS=2.24u
+ PD=2.24u
M$2 vdd i nq vdd sg13_lv_pmos L=0.13u W=0.78u AS=0.2652p AD=0.2652p PS=2.24u
+ PD=2.24u
.ENDS inv_x0
