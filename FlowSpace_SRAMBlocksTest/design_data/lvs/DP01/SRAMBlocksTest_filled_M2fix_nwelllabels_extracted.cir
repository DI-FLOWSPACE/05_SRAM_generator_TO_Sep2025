* Extracted by KLayout with SG13G2 LVS runset on : 24/10/2025 17:10

.SUBCKT DP01 vss vdd_block vdd_periph in_srout1 out_srout1 out_srin in_srin
+ clk2 out_latch2 out_latch1 clk1 out_shift1 out_l2s in_shift1 out_srout2
+ in_shift2 in_srout2 in_latch2 in_latch1 out_shift2
X$2 vss vdd_periph out_l2s out_shift1 out_srout1 out_srin clk1 out_latch1
+ in_latch1 in_shift1 in_srin in_srout1 vdd_block in_latch2 in_srout2 clk2
+ in_srin in_shift2 out_latch2 out_srout2 out_shift2 out_l2s out_srin
+ DP8TBlock_512x32_342A4WE_Test
.ENDS DP01

.SUBCKT DP8TBlock_512x32_342A4WE_Test vss vdd_periph out_l2s1 out_shift1
+ out_srout1 out_srin1 clk1 out_latch1 in_latch1 in_shift1 in_srin1 in_srout1
+ vdd_block in_latch2 in_srout2 clk2 in_srin2 in_shift2 out_latch2 out_srout2
+ out_shift2 out_l2s2 out_srin2
X$1 vss clk1 \$65 \$16 \$66 \$17 \$67 \$18 \$68 \$19 \$69 \$20 \$70 \$21 \$71
+ \$22 \$72 \$23 \$73 \$74 \$24 \$75 \$25 \$76 \$26 \$77 \$27 \$78 \$28 \$79
+ \$29 \$100 \$30 \$80 \$31 \$81 \$82 \$32 \$83 \$33 \$84 \$34 \$85 \$35 \$86
+ \$36 \$87 \$37 \$88 \$38 \$89 \$39 \$90 \$91 \$40 \$92 \$41 \$93 \$42 \$94
+ \$43 \$95 \$44 \$96 \$45 \$97 \$46 \$98 \$47 \$99 \$64 \$63 vdd_block \$61
+ \$62 \$58 \$60 \$59 \$57 \$56 \$151 \$103 \$102 \$104 \$150 \$149 \$105 \$106
+ \$148 \$132 \$153 \$154 \$155 \$156 \$176 \$177 \$178 \$136 \$158 \$159 \$160
+ \$161 \$179 \$180 \$181 \$141 \$163 \$164 \$165 \$166 \$183 \$184 \$185 \$145
+ \$168 \$169 \$170 \$171 \$186 \$187 \$188 \$131 \$133 \$107 \$108 \$109 \$110
+ \$111 \$112 \$134 \$135 \$137 \$113 \$114 \$115 \$116 \$117 \$118 \$138 \$140
+ \$142 \$119 \$120 \$121 \$122 \$123 \$124 \$143 \$144 \$146 \$125 \$126 \$127
+ \$128 \$129 \$130 \$147 clk2 DP8TBlock_512x32_342A4WE
X$2 vss vdd_periph out_shift2 out_l2s2 in_latch2 out_latch2 clk2 out_srin2
+ \$196 DP8TTimingOut_2SL
X$5 vss in_shift1 \$48 vdd_periph \$49 in_latch1 \$65 \$66 \$67 \$68 \$69 \$70
+ \$71 \$72 \$73 DP8TTimingIn_9SL
X$6 vss out_shift1 out_l2s1 \$5 vdd_periph \$4 out_latch1 \$16 \$17 \$18 \$19
+ \$20 \$21 \$22 \$23 DP8TTimingOut_8SL
X$7 vss in_shift2 \$173 vdd_periph \$167 in_latch2 \$147 \$130 \$129 \$128
+ \$127 \$126 \$125 \$146 \$144 DP8TTimingIn_9SL
X$8 vss out_shift2 out_l2s2 \$195 vdd_periph \$196 out_latch2 \$188 \$187 \$186
+ \$171 \$170 \$169 \$168 \$145 DP8TTimingOut_8SL
X$9 vss in_shift2 \$157 vdd_periph in_srout2 in_latch2 \$134 \$112 \$111 \$110
+ \$109 \$108 \$107 \$133 \$131 DP8TTimingIn_9SL
X$10 vss out_shift2 out_l2s2 out_srout2 vdd_periph \$191 out_latch2 \$178 \$177
+ \$176 \$156 \$155 \$154 \$153 \$132 DP8TTimingOut_8SL
X$11 vss in_shift2 \$167 vdd_periph \$162 in_latch2 \$143 \$124 \$123 \$122
+ \$121 \$120 \$119 \$142 \$140 DP8TTimingIn_9SL
X$12 vss out_shift2 out_l2s2 \$192 vdd_periph \$195 out_latch2 \$185 \$184
+ \$183 \$166 \$165 \$164 \$163 \$141 DP8TTimingOut_8SL
X$13 vss in_shift2 \$162 vdd_periph \$157 in_latch2 \$138 \$118 \$117 \$116
+ \$115 \$114 \$113 \$137 \$135 DP8TTimingIn_9SL
X$14 vss out_shift2 out_l2s2 \$191 vdd_periph \$192 out_latch2 \$181 \$180
+ \$179 \$161 \$160 \$159 \$158 \$136 DP8TTimingOut_8SL
X$15 vss in_shift1 \$49 vdd_periph \$50 in_latch1 \$74 \$75 \$76 \$77 \$78 \$79
+ \$100 \$80 \$81 DP8TTimingIn_9SL
X$16 vss out_shift1 out_l2s1 \$8 vdd_periph \$5 out_latch1 \$24 \$25 \$26 \$27
+ \$28 \$29 \$30 \$31 DP8TTimingOut_8SL
X$17 vss in_shift1 \$50 vdd_periph \$52 in_latch1 \$82 \$83 \$84 \$85 \$86 \$87
+ \$88 \$89 \$90 DP8TTimingIn_9SL
X$18 vss out_shift1 out_l2s1 \$9 vdd_periph \$8 out_latch1 \$32 \$33 \$34 \$35
+ \$36 \$37 \$38 \$39 DP8TTimingOut_8SL
X$19 vss in_shift1 \$52 vdd_periph in_srout1 in_latch1 \$91 \$92 \$93 \$94 \$95
+ \$96 \$97 \$98 \$99 DP8TTimingIn_9SL
X$20 vss out_shift1 out_l2s1 out_srout1 vdd_periph \$9 out_latch1 \$40 \$41
+ \$42 \$43 \$44 \$45 \$46 \$47 DP8TTimingOut_8SL
X$21 vss in_shift1 in_srin1 vdd_periph \$48 in_latch1 \$56 \$57 \$58 \$59 \$60
+ \$61 \$62 \$63 \$64 DP8TTimingIn_9SF
X$25 vss vdd_periph out_shift1 out_l2s1 in_latch1 out_latch1 clk1 out_srin1 \$4
+ DP8TTimingOut_2SL
X$27 vss in_shift2 in_srin2 vdd_periph \$173 in_latch2 \$151 \$103 \$102 \$150
+ \$149 \$105 \$104 \$106 \$148 DP8TTimingIn_9SF
.ENDS DP8TBlock_512x32_342A4WE_Test

.SUBCKT DP8TTimingOut_2SL vss vdd sr_shift l2s o[0] o[1] sr_latch sr_in sr_out
X$1 vss \$12 \$11 sr_shift vdd dff_x1
X$2 vss o[0] \$13 sr_latch vdd dff_x1
X$3 vdd vss l2s sr_in \$13 \$12 mux2_x1
X$4 vdd vss l2s \$11 \$16 \$15 mux2_x1
X$5 vss \$15 sr_out sr_shift vdd dff_x1
X$6 vss o[1] \$16 sr_latch vdd dff_x1
.ENDS DP8TTimingOut_2SL

.SUBCKT DP8TTimingOut_8SL vss sr_shift l2s sr_out vdd sr_in sr_latch o[0] o[1]
+ o[2] o[3] o[4] o[5] o[6] o[7]
X$1 vss \$9 \$10 sr_shift vdd dff_x1
X$2 vss o[0] \$25 sr_latch vdd dff_x1
X$3 vdd vss l2s sr_in \$25 \$9 mux2_x1
X$4 vdd vss l2s \$10 \$5 \$11 mux2_x1
X$5 vss \$11 \$12 sr_shift vdd dff_x1
X$6 vss o[1] \$5 sr_latch vdd dff_x1
X$7 vss \$13 \$14 sr_shift vdd dff_x1
X$8 vss o[2] \$26 sr_latch vdd dff_x1
X$9 vdd vss l2s \$12 \$26 \$13 mux2_x1
X$10 vdd vss l2s \$14 \$6 \$15 mux2_x1
X$11 vss \$15 \$16 sr_shift vdd dff_x1
X$12 vss o[3] \$6 sr_latch vdd dff_x1
X$13 vss \$17 \$18 sr_shift vdd dff_x1
X$14 vss o[4] \$28 sr_latch vdd dff_x1
X$15 vdd vss l2s \$16 \$28 \$17 mux2_x1
X$16 vdd vss l2s \$18 \$7 \$19 mux2_x1
X$17 vss \$19 \$20 sr_shift vdd dff_x1
X$18 vss o[5] \$7 sr_latch vdd dff_x1
X$19 vss \$21 \$22 sr_shift vdd dff_x1
X$20 vss o[6] \$29 sr_latch vdd dff_x1
X$21 vdd vss l2s \$20 \$29 \$21 mux2_x1
X$22 vdd vss l2s \$22 \$8 \$23 mux2_x1
X$23 vss \$23 sr_out sr_shift vdd dff_x1
X$24 vss o[7] \$8 sr_latch vdd dff_x1
.ENDS DP8TTimingOut_8SL

.SUBCKT DP8TTimingIn_9SL vss sr_shift sr_in vdd sr_out sr_latch i[0] i[1] i[2]
+ i[3] i[4] i[5] i[6] i[7] i[8]
X$1 vss sr_in \$5 sr_shift vdd dff_x1
X$2 vss \$5 i[0] sr_latch vdd dff_x1
X$3 vss \$5 \$6 sr_shift vdd dff_x1
X$4 vss \$6 i[1] sr_latch vdd dff_x1
X$5 vss \$6 \$7 sr_shift vdd dff_x1
X$6 vss \$7 i[2] sr_latch vdd dff_x1
X$7 vss \$7 \$8 sr_shift vdd dff_x1
X$8 vss \$8 i[3] sr_latch vdd dff_x1
X$9 vss \$8 \$9 sr_shift vdd dff_x1
X$10 vss \$9 i[4] sr_latch vdd dff_x1
X$11 vss \$9 \$10 sr_shift vdd dff_x1
X$12 vss \$10 i[5] sr_latch vdd dff_x1
X$13 vss \$10 \$11 sr_shift vdd dff_x1
X$14 vss \$11 i[6] sr_latch vdd dff_x1
X$15 vss \$11 \$12 sr_shift vdd dff_x1
X$16 vss \$12 i[7] sr_latch vdd dff_x1
X$17 vss \$12 sr_out sr_shift vdd dff_x1
X$18 vss sr_out i[8] sr_latch vdd dff_x1
.ENDS DP8TTimingIn_9SL

.SUBCKT DP8TTimingIn_9SF vss sr_shift sr_in vdd sr_out sr_latch i[8] i[7] i[6]
+ i[5] i[4] i[3] i[2] i[1] i[0]
X$1 vss sr_in \$5 sr_shift vdd dff_x1
X$2 vss \$5 i[8] sr_latch vdd dff_x1
X$3 vss \$5 \$6 sr_shift vdd dff_x1
X$4 vss \$6 i[7] sr_latch vdd dff_x1
X$5 vss \$6 \$7 sr_shift vdd dff_x1
X$6 vss \$7 i[6] sr_latch vdd dff_x1
X$7 vss \$7 \$8 sr_shift vdd dff_x1
X$8 vss \$8 i[5] sr_latch vdd dff_x1
X$9 vss \$8 \$9 sr_shift vdd dff_x1
X$10 vss \$9 i[4] sr_latch vdd dff_x1
X$11 vss \$9 \$10 sr_shift vdd dff_x1
X$12 vss \$10 i[3] sr_latch vdd dff_x1
X$13 vss \$10 \$11 sr_shift vdd dff_x1
X$14 vss \$11 i[2] sr_latch vdd dff_x1
X$15 vss \$11 \$12 sr_shift vdd dff_x1
X$16 vss \$12 i[1] sr_latch vdd dff_x1
X$17 vss \$12 sr_out sr_shift vdd dff_x1
X$18 vss sr_out i[0] sr_latch vdd dff_x1
.ENDS DP8TTimingIn_9SF

.SUBCKT DP8TBlock_512x32_342A4WE vss clk1 d1[0] q1[0] d1[1] q1[1] d1[2] q1[2]
+ d1[3] q1[3] d1[4] q1[4] d1[5] q1[5] d1[6] q1[6] d1[7] q1[7] we1[0] d1[8]
+ q1[8] d1[9] q1[9] d1[10] q1[10] d1[11] q1[11] d1[12] q1[12] d1[13] q1[13]
+ d1[14] q1[14] d1[15] q1[15] we1[1] d1[16] q1[16] d1[17] q1[17] d1[18] q1[18]
+ d1[19] q1[19] d1[20] q1[20] d1[21] q1[21] d1[22] q1[22] d1[23] q1[23] we1[2]
+ d1[24] q1[24] d1[25] q1[25] d1[26] q1[26] d1[27] q1[27] d1[28] q1[28] d1[29]
+ q1[29] d1[30] q1[30] d1[31] q1[31] we1[3] a1[0] a1[1] vdd a1[3] a1[2] a1[6]
+ a1[4] a1[5] a1[7] a1[8] a2[8] a2[7] a2[6] a2[2] a2[5] a2[4] a2[3] a2[1] a2[0]
+ q2[0] q2[1] q2[2] q2[3] q2[4] q2[5] q2[6] q2[7] q2[8] q2[9] q2[10] q2[11]
+ q2[12] q2[13] q2[14] q2[15] q2[16] q2[17] q2[18] q2[19] q2[20] q2[21] q2[22]
+ q2[23] q2[24] q2[25] q2[26] q2[27] q2[28] q2[29] q2[30] q2[31] we2[0] d2[0]
+ d2[1] d2[2] d2[3] d2[4] d2[5] d2[6] d2[7] we2[1] d2[8] d2[9] d2[10] d2[11]
+ d2[12] d2[13] d2[14] d2[15] we2[2] d2[16] d2[17] d2[18] d2[19] d2[20] d2[21]
+ d2[22] d2[23] we2[3] d2[24] d2[25] d2[26] d2[27] d2[28] d2[29] d2[30] d2[31]
+ clk2
X$1 vss clk1 \$71 \$72 vdd \$75 a1[0] \$81 \$82 a1[1] \$80 \$83 a1[2] \$114
+ \$113 \$115 \$109 \$108 \$112 \$111 \$107 \$110 a1[3] \$104 \$103 \$97 \$95
+ \$105 \$106 a1[4] \$100 \$99 \$102 \$98 \$101 \$96 \$127 \$136 \$133 \$131
+ a1[5] \$130 \$124 \$121 \$123 \$125 \$126 \$128 \$132 \$134 a1[6] \$118 \$122
+ \$135 \$137 \$129 a1[7] \$200 \$116 \$120 \$119 \$117 \$202 \$204 \$208 \$207
+ \$206 a1[8] \$199 \$198 \$197 \$196 \$203 \$205 \$224 \$210 \$191 \$192 \$193
+ \$194 \$225 \$226 \$227 \$223 \$229 \$222 \$228 \$233 \$232 \$230 \$209 \$220
+ \$219 \$218 \$217 \$216 \$215 \$214 \$213 \$221 \$212 \$231 \$195 \$190 \$211
+ \$201 \$322 \$327 \$299 \$304 \$309 \$294 \$332 \$315 \$316 \$295 \$296 \$297
+ \$313 \$312 \$311 \$305 \$306 \$307 \$308 \$310 \$292 \$298 \$300 \$301 \$302
+ \$293 \$331 \$314 \$303 \$326 \$330 \$325 \$324 \$328 \$329 \$323 \$321 \$320
+ \$319 \$318 \$317 DP8TRowPeriphery_3_4_2_wl1
X$2 vss d1[0] q1[0] d1[1] q1[1] d1[2] q1[2] d1[3] q1[3] d1[4] q1[4] d1[5] q1[5]
+ d1[6] q1[6] d1[7] q1[7] we1[0] d1[8] q1[8] d1[9] q1[9] d1[10] q1[10] d1[11]
+ q1[11] d1[12] q1[12] d1[13] q1[13] d1[14] q1[14] d1[15] q1[15] we1[1] d1[16]
+ q1[16] d1[17] q1[17] d1[18] q1[18] d1[19] q1[19] \$71 \$72 d1[20] q1[20]
+ d1[21] q1[21] d1[22] q1[22] d1[23] q1[23] we1[2] d1[24] q1[24] d1[25] q1[25]
+ d1[26] q1[26] d1[27] q1[27] d1[28] q1[28] d1[29] q1[29] d1[30] q1[30] d1[31]
+ q1[31] we1[3] vdd \$81 \$82 \$80 \$75 \$83 \$152 \$101 \$143 \$153 \$100 \$99
+ \$157 \$155 \$102 \$98 \$96 \$95 \$97 \$149 \$148 \$103 \$104 \$147 \$142
+ \$105 \$156 \$126 \$125 \$144 \$145 \$123 \$121 \$159 \$151 \$124 \$130 \$154
+ \$158 \$131 \$133 \$150 \$146 \$136 \$127 \$139 \$165 \$177 \$170 \$171 \$109
+ \$110 \$172 \$111 \$112 \$176 \$173 \$113 \$114 \$179 \$166 \$115 \$108 \$106
+ \$169 \$107 \$140 \$258 \$262 \$207 \$206 \$257 \$256 \$205 \$203 \$260 \$208
+ \$204 \$198 \$202 \$200 \$263 \$275 \$116 \$120 \$160 \$193 \$238 \$237 \$224
+ \$210 \$236 \$248 \$191 \$192 \$234 \$249 \$255 \$194 \$250 \$251 \$196 \$197
+ \$252 \$253 \$261 \$199 \$254 \$167 \$164 \$132 \$178 \$122 \$129 \$118 \$137
+ \$174 \$163 \$161 \$168 \$141 \$128 \$117 \$135 \$162 \$138 \$175 \$119 \$134
+ \$220 \$274 \$240 \$218 \$190 \$219 \$235 \$271 \$268 \$278 \$195 \$217 \$265
+ \$209 \$201 \$276 \$247 \$259 \$222 \$277 \$213 \$267 \$269 \$214 \$212 \$215
+ \$270 \$211 \$273 \$221 \$216 \$272 \$349 \$231 \$266 \$227 \$229 \$243 \$242
+ \$299 \$223 \$304 \$345 \$344 \$241 \$239 \$336 \$226 \$225 \$309 \$294 \$232
+ \$228 \$264 \$246 \$322 \$233 \$327 \$245 \$244 \$339 \$230 \$308 \$373 \$366
+ \$305 \$331 \$306 \$375 \$330 \$357 \$307 \$374 \$302 \$376 \$365 \$310 \$329
+ \$311 \$362 \$328 \$298 \$370 \$314 \$303 \$369 \$368 \$293 \$358 \$367 \$364
+ \$300 \$301 \$360 \$359 \$371 \$292 \$296 \$332 \$361 \$325 \$315 \$337 \$295
+ \$324 \$363 \$352 \$355 \$338 \$334 \$316 \$297 \$356 \$312 \$333 \$313 \$348
+ \$377 \$346 \$347 \$335 \$372 \$323 \$326 q2[0] q2[1] q2[2] q2[3] q2[4] q2[5]
+ q2[6] q2[7] q2[8] q2[9] q2[10] q2[11] q2[12] q2[13] q2[14] q2[15] \$319 \$353
+ \$354 \$320 \$340 \$341 \$342 \$343 \$286 \$317 \$351 \$321 \$350 \$318
+ q2[16] q2[17] q2[18] q2[19] q2[20] q2[21] q2[22] q2[23] q2[24] q2[25] q2[26]
+ q2[27] q2[28] q2[29] q2[30] q2[31] we2[0] d2[0] d2[1] d2[2] d2[3] d2[4] d2[5]
+ d2[6] d2[7] we2[1] d2[8] d2[9] d2[10] d2[11] \$452 \$453 d2[12] d2[13] d2[14]
+ d2[15] we2[2] d2[16] d2[17] d2[18] d2[19] d2[20] d2[21] d2[22] d2[23] we2[3]
+ d2[24] d2[25] d2[26] d2[27] d2[28] d2[29] d2[30] d2[31]
+ DP8TColumnBlock_128R32B4M4W
X$3 vss clk2 \$453 \$452 vdd \$286 a2[0] \$340 \$341 a2[1] \$342 \$343 a2[2]
+ \$351 \$353 \$350 \$354 \$356 \$348 \$334 \$338 \$335 a2[3] \$373 \$374 \$370
+ \$369 \$376 \$333 a2[4] \$360 \$364 \$367 \$368 \$359 \$358 \$366 \$375 \$357
+ \$371 a2[5] \$365 \$362 \$363 \$377 \$372 \$352 \$355 \$361 \$337 a2[6] \$345
+ \$344 \$347 \$346 \$336 a2[7] \$240 \$235 \$259 \$349 \$339 \$265 \$268 \$272
+ \$270 \$267 a2[8] \$273 \$266 \$274 \$271 \$277 \$269 \$245 \$246 \$264 \$247
+ \$276 \$278 \$244 \$243 \$242 \$241 \$239 \$234 \$248 \$236 \$237 \$238 \$249
+ \$250 \$251 \$252 \$253 \$254 \$255 \$256 \$257 \$262 \$258 \$263 \$275 \$261
+ \$260 \$160 \$161 \$162 \$163 \$164 \$178 \$167 \$168 \$175 \$174 \$138 \$141
+ \$144 \$145 \$159 \$151 \$139 \$146 \$150 \$158 \$156 \$165 \$155 \$157 \$153
+ \$143 \$154 \$148 \$149 \$152 \$169 \$147 \$170 \$171 \$140 \$142 \$172 \$173
+ \$176 \$177 \$179 \$166 DP8TRowPeriphery_3_4_2_wl2
.ENDS DP8TBlock_512x32_342A4WE

.SUBCKT mux2_x1 vdd vss cmd i0 i1 q
M$1 \$1 cmd vss vss sg13_lv_nmos L=0.13u W=0.78u AS=0.2652p AD=0.1482p PS=2.24u
+ PD=1.16u
M$2 vss i0 \$9 vss sg13_lv_nmos L=0.13u W=0.78u AS=0.1482p AD=0.1482p PS=1.16u
+ PD=1.16u
M$3 \$9 \$1 \$6 vss sg13_lv_nmos L=0.13u W=0.78u AS=0.1482p AD=0.195p PS=1.16u
+ PD=1.28u
M$4 \$6 cmd \$10 vss sg13_lv_nmos L=0.13u W=0.78u AS=0.195p AD=0.1482p PS=1.28u
+ PD=1.16u
M$5 \$10 i1 vss vss sg13_lv_nmos L=0.13u W=0.78u AS=0.1482p AD=0.2092p PS=1.16u
+ PD=1.48u
M$6 vss \$6 q vss sg13_lv_nmos L=0.13u W=1.07u AS=0.2092p AD=0.3638p PS=1.48u
+ PD=2.82u
M$7 \$1 cmd vdd vdd sg13_lv_pmos L=0.13u W=0.78u AS=0.2652p AD=0.1482p PS=2.24u
+ PD=1.16u
M$8 vdd i0 \$11 vdd sg13_lv_pmos L=0.13u W=0.78u AS=0.1482p AD=0.1482p PS=1.16u
+ PD=1.16u
M$9 \$11 cmd \$6 vdd sg13_lv_pmos L=0.13u W=0.78u AS=0.1482p AD=0.195p PS=1.16u
+ PD=1.28u
M$10 \$6 \$1 \$12 vdd sg13_lv_pmos L=0.13u W=0.78u AS=0.195p AD=0.1482p
+ PS=1.28u PD=1.16u
M$11 vdd i1 \$12 vdd sg13_lv_pmos L=0.13u W=0.78u AS=0.2075p AD=0.1482p
+ PS=1.47u PD=1.16u
M$12 vdd \$6 q vdd sg13_lv_pmos L=0.13u W=1.06u AS=0.2075p AD=0.3604p PS=1.47u
+ PD=2.8u
.ENDS mux2_x1

.SUBCKT DP8TRowPeriphery_3_4_2_wl2 vss clk columnclk we_en vdd precharge_n a[0]
+ mux[0] mux[1] a[1] mux[2] mux[3] a[2] wl[126] wl[125] wl[127] wl[124] wl[123]
+ wl[122] wl[121] wl[120] wl[119] a[3] wl[115] wl[116] wl[114] wl[113] wl[117]
+ wl[118] a[4] wl[109] wl[110] wl[111] wl[112] wl[108] wl[107] wl[106] wl[105]
+ wl[104] wl[103] a[5] wl[102] wl[101] wl[100] wl[99] wl[98] wl[94] wl[95]
+ wl[97] wl[96] a[6] wl[89] wl[90] wl[93] wl[92] wl[91] a[7] wl[84] wl[85]
+ wl[86] wl[87] wl[88] wl[83] wl[82] wl[81] wl[80] wl[79] a[8] wl[76] wl[75]
+ wl[74] wl[73] wl[77] wl[78] wl[67] wl[68] wl[69] wl[70] wl[71] wl[72] wl[66]
+ wl[65] wl[64] wl[63] wl[62] wl[57] wl[58] wl[59] wl[60] wl[61] wl[56] wl[55]
+ wl[54] wl[53] wl[52] wl[51] wl[50] wl[49] wl[48] wl[44] wl[47] wl[43] wl[42]
+ wl[45] wl[46] wl[41] wl[40] wl[39] wl[38] wl[37] wl[36] wl[35] wl[34] wl[33]
+ wl[32] wl[31] wl[30] wl[29] wl[28] wl[27] wl[26] wl[21] wl[22] wl[23] wl[24]
+ wl[25] wl[20] wl[16] wl[17] wl[18] wl[19] wl[15] wl[12] wl[13] wl[14] wl[8]
+ wl[11] wl[7] wl[6] wl[9] wl[10] wl[5] wl[4] wl[3] wl[2] wl[1] wl[0]
X$1 vss vdd clk \$7 wl_en precharge_n columnclk we_en DP8TClockGenerator_8S1R
X$2 vss a[2] vdd wl[126] wl[127] wl[125] wl[123] wl[122] wl[124] wl[121]
+ wl[120] wl[119] wl[118] a[3] wl[116] wl[117] wl[113] wl[114] wl[115] wl[111]
+ wl[112] a[4] wl[109] wl[110] wl[108] wl[106] wl[105] wl[107] \$7 wl[104]
+ wl[103] a[5] wl[101] wl[100] wl[102] wl[98] wl[99] wl[97] wl[96] a[6] wl[94]
+ wl[93] wl[95] wl[91] wl[92] wl[90] wl[88] wl[89] wl[87] wl[86] wl[85] a[7]
+ wl[84] wl[83] wl[82] wl[81] wl[80] wl[78] wl[77] wl[79] a[8] wl[76] wl[75]
+ wl[74] wl[73] wl[72] wl[70] wl[69] wl[71] wl_en wl[68] wl[67] wl[66] wl[64]
+ wl[65] wl[62] wl[63] wl[61] wl[60] wl[59] wl[58] wl[57] wl[56] wl[54] wl[53]
+ wl[55] wl[52] wl[51] wl[50] wl[48] wl[49] wl[46] wl[47] wl[45] wl[44] wl[43]
+ wl[42] wl[41] wl[40] wl[38] wl[37] wl[39] wl[36] wl[35] wl[34] wl[32] wl[33]
+ wl[30] wl[31] wl[29] wl[28] wl[27] wl[26] wl[24] wl[25] wl[20] wl[21] wl[22]
+ wl[23] wl[19] wl[18] wl[16] wl[17] wl[14] wl[15] wl[13] wl[12] wl[11] wl[10]
+ wl[9] wl[8] wl[7] wl[6] wl[4] wl[5] wl[2] wl[3] wl[0] wl[1]
+ DP8TRowDecoder_3_4B_wl2
X$3 vss vdd a[0] a[1] mux[0] mux[1] mux[2] mux[3] \$7 DP8TLatchedDecoder_2A2R
.ENDS DP8TRowPeriphery_3_4_2_wl2

.SUBCKT DP8TColumnBlock_128R32B4M4W vss d1[0] q1[0] d1[1] q1[1] d1[2] q1[2]
+ d1[3] q1[3] d1[4] q1[4] d1[5] q1[5] d1[6] q1[6] d1[7] q1[7] we1[0] d1[8]
+ q1[8] d1[9] q1[9] d1[10] q1[10] d1[11] q1[11] d1[12] q1[12] d1[13] q1[13]
+ d1[14] q1[14] d1[15] q1[15] we1[1] d1[16] q1[16] d1[17] q1[17] d1[18] q1[18]
+ d1[19] q1[19] clk1 we_en1 d1[20] q1[20] d1[21] q1[21] d1[22] q1[22] d1[23]
+ q1[23] we1[2] d1[24] q1[24] d1[25] q1[25] d1[26] q1[26] d1[27] q1[27] d1[28]
+ q1[28] d1[29] q1[29] d1[30] q1[30] d1[31] q1[31] we1[3] vdd mux1[0] mux1[1]
+ mux1[2] precharge1_n mux1[3] wl1[14] wl2[19] wl1[19] wl1[18] wl2[18] wl2[17]
+ wl1[17] wl1[16] wl2[16] wl2[15] wl2[20] wl2[14] wl2[13] wl1[13] wl1[12]
+ wl2[12] wl2[11] wl1[11] wl1[10] wl2[10] wl1[25] wl2[30] wl2[29] wl1[29]
+ wl1[28] wl2[28] wl2[27] wl1[27] wl1[26] wl2[26] wl2[25] wl1[15] wl1[24]
+ wl2[24] wl2[23] wl1[23] wl1[22] wl2[22] wl2[21] wl1[21] wl1[20] wl1[2] wl1[7]
+ wl1[6] wl2[6] wl2[5] wl1[5] wl2[4] wl2[3] wl1[3] wl1[4] wl2[2] wl2[1] wl1[1]
+ wl1[0] wl2[0] wl2[7] wl2[9] wl1[8] wl2[8] wl1[9] wl1[47] wl1[44] wl2[47]
+ wl2[48] wl1[48] wl1[49] wl2[49] wl2[50] wl1[46] wl2[46] wl2[45] wl2[52]
+ wl2[44] wl2[43] wl1[43] wl1[42] wl2[42] wl2[41] wl1[41] wl2[56] wl1[61]
+ wl1[60] wl2[60] wl2[59] wl1[59] wl1[58] wl2[58] wl2[57] wl1[57] wl1[56]
+ wl1[50] wl2[55] wl1[55] wl1[54] wl2[54] wl2[53] wl1[53] wl1[52] wl1[45]
+ wl2[51] wl1[51] wl1[35] wl1[37] wl2[32] wl1[36] wl2[37] wl2[36] wl2[38]
+ wl2[35] wl1[32] wl1[38] wl1[40] wl1[34] wl1[30] wl2[31] wl2[39] wl2[34]
+ wl1[39] wl1[31] wl1[33] wl2[40] wl2[33] wl2[72] wl1[74] wl1[84] wl2[74]
+ wl2[82] wl2[73] wl1[85] wl1[73] wl1[82] wl1[72] wl2[85] wl2[75] wl1[83]
+ wl2[71] wl2[86] wl1[71] wl1[70] wl1[86] wl2[70] wl1[77] wl2[79] wl1[79]
+ wl1[78] wl2[78] wl2[80] wl2[77] wl1[80] wl2[81] wl1[76] wl2[83] wl2[76]
+ wl1[81] wl1[87] wl2[84] wl1[75] wl2[63] wl2[65] wl1[65] wl1[64] wl2[89]
+ wl2[64] wl2[90] wl1[89] wl1[90] wl1[63] wl1[62] wl1[91] wl2[62] wl2[61]
+ wl2[91] wl2[92] wl2[67] wl2[69] wl1[69] wl1[68] wl2[87] wl2[68] wl2[88]
+ wl1[67] wl1[66] wl1[88] wl2[66] wl2[103] wl1[115] wl1[106] wl2[106] wl2[115]
+ wl2[105] wl1[105] wl2[116] wl1[104] wl2[104] wl1[116] wl2[108] wl1[117]
+ wl1[102] wl2[102] wl2[117] wl2[101] wl1[101] wl2[118] wl2[111] wl1[114]
+ wl2[114] wl2[113] wl1[113] wl1[112] wl2[112] wl1[107] wl1[111] wl1[110]
+ wl2[110] wl2[109] wl1[109] wl1[108] wl1[103] wl2[107] wl2[97] wl2[93] wl1[97]
+ wl2[120] wl2[94] wl1[96] wl2[96] wl2[121] wl1[100] wl1[94] wl1[95] wl1[120]
+ wl1[121] wl2[95] wl2[98] wl1[123] wl2[100] wl1[118] wl2[99] wl1[122] wl1[99]
+ wl1[92] wl1[93] wl1[119] wl1[98] wl2[122] wl2[119] q2[0] q2[1] q2[2] q2[3]
+ q2[4] q2[5] q2[6] q2[7] q2[8] q2[9] q2[10] q2[11] q2[12] q2[13] q2[14] q2[15]
+ wl2[125] wl1[125] wl1[124] wl2[124] mux2[0] mux2[1] mux2[2] mux2[3]
+ precharge2_n wl2[127] wl1[126] wl2[123] wl1[127] wl2[126] q2[16] q2[17]
+ q2[18] q2[19] q2[20] q2[21] q2[22] q2[23] q2[24] q2[25] q2[26] q2[27] q2[28]
+ q2[29] q2[30] q2[31] we2[0] d2[0] d2[1] d2[2] d2[3] d2[4] d2[5] d2[6] d2[7]
+ we2[1] d2[8] d2[9] d2[10] d2[11] we_en2 clk2 d2[12] d2[13] d2[14] d2[15]
+ we2[2] d2[16] d2[17] d2[18] d2[19] d2[20] d2[21] d2[22] d2[23] we2[3] d2[24]
+ d2[25] d2[26] d2[27] d2[28] d2[29] d2[30] d2[31]
X$1 vss d1[8] q1[8] d1[9] q1[9] d1[10] q1[10] d1[11] q1[11] d1[12] q1[12]
+ d1[13] q1[13] d1[14] q1[14] d1[15] q1[15] we1[1] clk1 we_en1 vdd mux1[0]
+ wl2[17] wl1[2] wl1[5] wl2[2] wl1[12] wl2[0] wl2[1] wl1[1] wl1[0] wl1[8]
+ wl1[18] wl2[12] wl2[18] wl2[11] wl1[19] wl1[11] wl1[10] wl2[10] wl2[9] wl1[9]
+ wl1[3] wl2[8] wl2[7] wl1[7] wl1[6] wl2[6] wl2[5] wl2[19] wl1[4] wl2[4] wl2[3]
+ wl1[17] wl2[14] wl2[13] precharge1_n mux1[3] mux1[2] mux1[1] wl1[14] wl1[13]
+ wl1[15] wl2[15] wl2[16] wl1[16] wl1[25] wl2[20] wl1[24] wl2[25] wl2[26]
+ wl2[24] wl1[26] wl1[27] wl2[27] wl2[23] wl2[28] wl1[28] wl1[22] wl2[22]
+ wl2[21] wl1[21] wl1[20] wl1[23] wl1[35] wl1[34] wl2[34] wl2[33] wl1[33]
+ wl1[32] wl1[29] wl2[32] wl2[36] wl1[36] wl2[29] wl2[30] wl2[31] wl1[30]
+ wl1[31] wl2[35] wl2[45] wl1[43] wl1[40] wl1[45] wl1[41] wl1[44] wl2[41]
+ wl2[44] wl2[42] wl2[43] wl1[42] wl2[39] wl1[39] wl1[38] wl2[38] wl2[37]
+ wl1[37] wl2[40] wl2[49] wl2[50] wl1[49] wl1[50] wl1[51] wl2[51] wl1[48]
+ wl2[52] wl2[53] wl1[52] wl2[48] wl1[53] wl2[46] wl1[46] wl2[47] wl1[47]
+ wl1[62] wl2[60] wl2[62] wl2[57] wl2[61] wl2[58] wl1[61] wl1[58] wl1[59]
+ wl1[60] wl2[59] wl1[56] wl2[56] wl2[55] wl1[55] wl1[54] wl2[54] wl1[57]
+ wl1[66] wl1[67] wl2[66] wl2[67] wl2[68] wl1[68] wl2[65] wl1[69] wl1[70]
+ wl2[69] wl1[65] wl2[70] wl2[64] wl1[63] wl2[63] wl1[64] wl2[79] wl1[77]
+ wl1[79] wl1[74] wl1[78] wl1[75] wl2[78] wl2[75] wl2[76] wl2[77] wl1[76]
+ wl2[73] wl1[73] wl1[72] wl2[72] wl2[71] wl1[71] wl2[74] wl2[83] wl2[84]
+ wl1[83] wl1[84] wl1[85] wl2[85] wl1[82] wl2[86] wl2[87] wl1[86] wl2[82]
+ wl1[87] wl1[81] wl1[80] wl2[81] wl2[80] wl1[94] wl2[91] wl2[92] wl1[92]
+ wl1[93] wl2[95] wl2[93] wl1[95] wl2[94] wl1[90] wl2[90] wl2[89] wl1[89]
+ wl1[88] wl2[88] wl1[91] wl1[100] wl1[101] wl2[100] wl2[101] wl2[102] wl1[102]
+ wl2[99] wl1[103] wl1[104] wl2[103] wl1[99] wl2[104] wl2[98] wl2[96] wl1[96]
+ wl2[97] wl1[98] wl1[97] wl1[112] wl2[111] wl1[108] wl1[109] wl2[109] wl2[112]
+ wl2[110] wl1[110] wl1[111] wl2[107] wl1[107] wl1[106] wl2[106] wl2[105]
+ wl1[105] wl2[108] wl2[117] wl2[118] wl1[117] wl1[118] wl1[119] wl2[119]
+ wl1[116] wl2[120] wl2[121] wl1[120] wl2[116] wl1[121] wl1[115] wl1[113]
+ wl2[113] wl1[114] wl2[115] wl2[114] wl1[123] wl2[123] wl1[122] wl2[122]
+ wl2[124] wl1[124] wl1[125] wl2[125] wl2[127] wl1[127] wl1[126] wl2[126]
+ we_en2 clk2 we2[1] q2[8] d2[8] q2[9] d2[9] q2[10] d2[10] q2[11] d2[11]
+ mux2[3] mux2[2] precharge2_n mux2[1] mux2[0] q2[12] d2[12] q2[13] d2[13]
+ q2[14] d2[14] q2[15] d2[15] DP8TColumn_128R8B4M
X$2 vss d1[0] q1[0] d1[1] q1[1] d1[2] q1[2] d1[3] q1[3] d1[4] q1[4] d1[5] q1[5]
+ d1[6] q1[6] d1[7] q1[7] we1[0] clk1 we_en1 vdd mux1[0] wl2[17] wl1[2] wl1[5]
+ wl2[2] wl1[12] wl2[0] wl2[1] wl1[1] wl1[0] wl1[8] wl1[18] wl2[12] wl2[18]
+ wl2[11] wl1[19] wl1[11] wl1[10] wl2[10] wl2[9] wl1[9] wl1[3] wl2[8] wl2[7]
+ wl1[7] wl1[6] wl2[6] wl2[5] wl2[19] wl1[4] wl2[4] wl2[3] wl1[17] wl2[14]
+ wl2[13] precharge1_n mux1[3] mux1[2] mux1[1] wl1[14] wl1[13] wl1[15] wl2[15]
+ wl2[16] wl1[16] wl1[25] wl2[20] wl1[24] wl2[25] wl2[26] wl2[24] wl1[26]
+ wl1[27] wl2[27] wl2[23] wl2[28] wl1[28] wl1[22] wl2[22] wl2[21] wl1[21]
+ wl1[20] wl1[23] wl1[35] wl1[34] wl2[34] wl2[33] wl1[33] wl1[32] wl1[29]
+ wl2[32] wl2[36] wl1[36] wl2[29] wl2[30] wl2[31] wl1[30] wl1[31] wl2[35]
+ wl2[45] wl1[43] wl1[40] wl1[45] wl1[41] wl1[44] wl2[41] wl2[44] wl2[42]
+ wl2[43] wl1[42] wl2[39] wl1[39] wl1[38] wl2[38] wl2[37] wl1[37] wl2[40]
+ wl2[49] wl2[50] wl1[49] wl1[50] wl1[51] wl2[51] wl1[48] wl2[52] wl2[53]
+ wl1[52] wl2[48] wl1[53] wl2[46] wl1[46] wl2[47] wl1[47] wl1[62] wl2[60]
+ wl2[62] wl2[57] wl2[61] wl2[58] wl1[61] wl1[58] wl1[59] wl1[60] wl2[59]
+ wl1[56] wl2[56] wl2[55] wl1[55] wl1[54] wl2[54] wl1[57] wl1[66] wl1[67]
+ wl2[66] wl2[67] wl2[68] wl1[68] wl2[65] wl1[69] wl1[70] wl2[69] wl1[65]
+ wl2[70] wl2[64] wl1[63] wl2[63] wl1[64] wl2[79] wl1[77] wl1[79] wl1[74]
+ wl1[78] wl1[75] wl2[78] wl2[75] wl2[76] wl2[77] wl1[76] wl2[73] wl1[73]
+ wl1[72] wl2[72] wl2[71] wl1[71] wl2[74] wl2[83] wl2[84] wl1[83] wl1[84]
+ wl1[85] wl2[85] wl1[82] wl2[86] wl2[87] wl1[86] wl2[82] wl1[87] wl1[81]
+ wl1[80] wl2[81] wl2[80] wl1[94] wl2[91] wl2[92] wl1[92] wl1[93] wl2[95]
+ wl2[93] wl1[95] wl2[94] wl1[90] wl2[90] wl2[89] wl1[89] wl1[88] wl2[88]
+ wl1[91] wl1[100] wl1[101] wl2[100] wl2[101] wl2[102] wl1[102] wl2[99]
+ wl1[103] wl1[104] wl2[103] wl1[99] wl2[104] wl2[98] wl2[96] wl1[96] wl2[97]
+ wl1[98] wl1[97] wl1[112] wl2[111] wl1[108] wl1[109] wl2[109] wl2[112]
+ wl2[110] wl1[110] wl1[111] wl2[107] wl1[107] wl1[106] wl2[106] wl2[105]
+ wl1[105] wl2[108] wl2[117] wl2[118] wl1[117] wl1[118] wl1[119] wl2[119]
+ wl1[116] wl2[120] wl2[121] wl1[120] wl2[116] wl1[121] wl1[115] wl1[113]
+ wl2[113] wl1[114] wl2[115] wl2[114] wl1[123] wl2[123] wl1[122] wl2[122]
+ wl2[124] wl1[124] wl1[125] wl2[125] wl2[127] wl1[127] wl1[126] wl2[126]
+ we_en2 clk2 we2[0] q2[0] d2[0] q2[1] d2[1] q2[2] d2[2] q2[3] d2[3] mux2[3]
+ mux2[2] precharge2_n mux2[1] mux2[0] q2[4] d2[4] q2[5] d2[5] q2[6] d2[6]
+ q2[7] d2[7] DP8TColumn_128R8B4M
X$3 vss d1[16] q1[16] d1[17] q1[17] d1[18] q1[18] d1[19] q1[19] d1[20] q1[20]
+ d1[21] q1[21] d1[22] q1[22] d1[23] q1[23] we1[2] clk1 we_en1 vdd mux1[0]
+ wl2[17] wl1[2] wl1[5] wl2[2] wl1[12] wl2[0] wl2[1] wl1[1] wl1[0] wl1[8]
+ wl1[18] wl2[12] wl2[18] wl2[11] wl1[19] wl1[11] wl1[10] wl2[10] wl2[9] wl1[9]
+ wl1[3] wl2[8] wl2[7] wl1[7] wl1[6] wl2[6] wl2[5] wl2[19] wl1[4] wl2[4] wl2[3]
+ wl1[17] wl2[14] wl2[13] precharge1_n mux1[3] mux1[2] mux1[1] wl1[14] wl1[13]
+ wl1[15] wl2[15] wl2[16] wl1[16] wl1[25] wl2[20] wl1[24] wl2[25] wl2[26]
+ wl2[24] wl1[26] wl1[27] wl2[27] wl2[23] wl2[28] wl1[28] wl1[22] wl2[22]
+ wl2[21] wl1[21] wl1[20] wl1[23] wl1[35] wl1[34] wl2[34] wl2[33] wl1[33]
+ wl1[32] wl1[29] wl2[32] wl2[36] wl1[36] wl2[29] wl2[30] wl2[31] wl1[30]
+ wl1[31] wl2[35] wl2[45] wl1[43] wl1[40] wl1[45] wl1[41] wl1[44] wl2[41]
+ wl2[44] wl2[42] wl2[43] wl1[42] wl2[39] wl1[39] wl1[38] wl2[38] wl2[37]
+ wl1[37] wl2[40] wl2[49] wl2[50] wl1[49] wl1[50] wl1[51] wl2[51] wl1[48]
+ wl2[52] wl2[53] wl1[52] wl2[48] wl1[53] wl2[46] wl1[46] wl2[47] wl1[47]
+ wl1[62] wl2[60] wl2[62] wl2[57] wl2[61] wl2[58] wl1[61] wl1[58] wl1[59]
+ wl1[60] wl2[59] wl1[56] wl2[56] wl2[55] wl1[55] wl1[54] wl2[54] wl1[57]
+ wl1[66] wl1[67] wl2[66] wl2[67] wl2[68] wl1[68] wl2[65] wl1[69] wl1[70]
+ wl2[69] wl1[65] wl2[70] wl2[64] wl1[63] wl2[63] wl1[64] wl2[79] wl1[77]
+ wl1[79] wl1[74] wl1[78] wl1[75] wl2[78] wl2[75] wl2[76] wl2[77] wl1[76]
+ wl2[73] wl1[73] wl1[72] wl2[72] wl2[71] wl1[71] wl2[74] wl2[83] wl2[84]
+ wl1[83] wl1[84] wl1[85] wl2[85] wl1[82] wl2[86] wl2[87] wl1[86] wl2[82]
+ wl1[87] wl1[81] wl1[80] wl2[81] wl2[80] wl1[94] wl2[91] wl2[92] wl1[92]
+ wl1[93] wl2[95] wl2[93] wl1[95] wl2[94] wl1[90] wl2[90] wl2[89] wl1[89]
+ wl1[88] wl2[88] wl1[91] wl1[100] wl1[101] wl2[100] wl2[101] wl2[102] wl1[102]
+ wl2[99] wl1[103] wl1[104] wl2[103] wl1[99] wl2[104] wl2[98] wl2[96] wl1[96]
+ wl2[97] wl1[98] wl1[97] wl1[112] wl2[111] wl1[108] wl1[109] wl2[109] wl2[112]
+ wl2[110] wl1[110] wl1[111] wl2[107] wl1[107] wl1[106] wl2[106] wl2[105]
+ wl1[105] wl2[108] wl2[117] wl2[118] wl1[117] wl1[118] wl1[119] wl2[119]
+ wl1[116] wl2[120] wl2[121] wl1[120] wl2[116] wl1[121] wl1[115] wl1[113]
+ wl2[113] wl1[114] wl2[115] wl2[114] wl1[123] wl2[123] wl1[122] wl2[122]
+ wl2[124] wl1[124] wl1[125] wl2[125] wl2[127] wl1[127] wl1[126] wl2[126]
+ we_en2 clk2 we2[2] q2[16] d2[16] q2[17] d2[17] q2[18] d2[18] q2[19] d2[19]
+ mux2[3] mux2[2] precharge2_n mux2[1] mux2[0] q2[20] d2[20] q2[21] d2[21]
+ q2[22] d2[22] q2[23] d2[23] DP8TColumn_128R8B4M
X$4 vss d1[24] q1[24] d1[25] q1[25] d1[26] q1[26] d1[27] q1[27] d1[28] q1[28]
+ d1[29] q1[29] d1[30] q1[30] d1[31] q1[31] we1[3] clk1 we_en1 vdd mux1[0]
+ wl2[17] wl1[2] wl1[5] wl2[2] wl1[12] wl2[0] wl2[1] wl1[1] wl1[0] wl1[8]
+ wl1[18] wl2[12] wl2[18] wl2[11] wl1[19] wl1[11] wl1[10] wl2[10] wl2[9] wl1[9]
+ wl1[3] wl2[8] wl2[7] wl1[7] wl1[6] wl2[6] wl2[5] wl2[19] wl1[4] wl2[4] wl2[3]
+ wl1[17] wl2[14] wl2[13] precharge1_n mux1[3] mux1[2] mux1[1] wl1[14] wl1[13]
+ wl1[15] wl2[15] wl2[16] wl1[16] wl1[25] wl2[20] wl1[24] wl2[25] wl2[26]
+ wl2[24] wl1[26] wl1[27] wl2[27] wl2[23] wl2[28] wl1[28] wl1[22] wl2[22]
+ wl2[21] wl1[21] wl1[20] wl1[23] wl1[35] wl1[34] wl2[34] wl2[33] wl1[33]
+ wl1[32] wl1[29] wl2[32] wl2[36] wl1[36] wl2[29] wl2[30] wl2[31] wl1[30]
+ wl1[31] wl2[35] wl2[45] wl1[43] wl1[40] wl1[45] wl1[41] wl1[44] wl2[41]
+ wl2[44] wl2[42] wl2[43] wl1[42] wl2[39] wl1[39] wl1[38] wl2[38] wl2[37]
+ wl1[37] wl2[40] wl2[49] wl2[50] wl1[49] wl1[50] wl1[51] wl2[51] wl1[48]
+ wl2[52] wl2[53] wl1[52] wl2[48] wl1[53] wl2[46] wl1[46] wl2[47] wl1[47]
+ wl1[62] wl2[60] wl2[62] wl2[57] wl2[61] wl2[58] wl1[61] wl1[58] wl1[59]
+ wl1[60] wl2[59] wl1[56] wl2[56] wl2[55] wl1[55] wl1[54] wl2[54] wl1[57]
+ wl1[66] wl1[67] wl2[66] wl2[67] wl2[68] wl1[68] wl2[65] wl1[69] wl1[70]
+ wl2[69] wl1[65] wl2[70] wl2[64] wl1[63] wl2[63] wl1[64] wl2[79] wl1[77]
+ wl1[79] wl1[74] wl1[78] wl1[75] wl2[78] wl2[75] wl2[76] wl2[77] wl1[76]
+ wl2[73] wl1[73] wl1[72] wl2[72] wl2[71] wl1[71] wl2[74] wl2[83] wl2[84]
+ wl1[83] wl1[84] wl1[85] wl2[85] wl1[82] wl2[86] wl2[87] wl1[86] wl2[82]
+ wl1[87] wl1[81] wl1[80] wl2[81] wl2[80] wl1[94] wl2[91] wl2[92] wl1[92]
+ wl1[93] wl2[95] wl2[93] wl1[95] wl2[94] wl1[90] wl2[90] wl2[89] wl1[89]
+ wl1[88] wl2[88] wl1[91] wl1[100] wl1[101] wl2[100] wl2[101] wl2[102] wl1[102]
+ wl2[99] wl1[103] wl1[104] wl2[103] wl1[99] wl2[104] wl2[98] wl2[96] wl1[96]
+ wl2[97] wl1[98] wl1[97] wl1[112] wl2[111] wl1[108] wl1[109] wl2[109] wl2[112]
+ wl2[110] wl1[110] wl1[111] wl2[107] wl1[107] wl1[106] wl2[106] wl2[105]
+ wl1[105] wl2[108] wl2[117] wl2[118] wl1[117] wl1[118] wl1[119] wl2[119]
+ wl1[116] wl2[120] wl2[121] wl1[120] wl2[116] wl1[121] wl1[115] wl1[113]
+ wl2[113] wl1[114] wl2[115] wl2[114] wl1[123] wl2[123] wl1[122] wl2[122]
+ wl2[124] wl1[124] wl1[125] wl2[125] wl2[127] wl1[127] wl1[126] wl2[126]
+ we_en2 clk2 we2[3] q2[24] d2[24] q2[25] d2[25] q2[26] d2[26] q2[27] d2[27]
+ mux2[3] mux2[2] precharge2_n mux2[1] mux2[0] q2[28] d2[28] q2[29] d2[29]
+ q2[30] d2[30] q2[31] d2[31] DP8TColumn_128R8B4M
.ENDS DP8TColumnBlock_128R32B4M4W

.SUBCKT DP8TRowPeriphery_3_4_2_wl1 vss clk columnclk we_en vdd precharge_n a[0]
+ mux[0] mux[1] a[1] mux[2] mux[3] a[2] wl[1] wl[2] wl[0] wl[6] wl[7] wl[3]
+ wl[4] wl[8] wl[5] a[3] wl[11] wl[12] wl[13] wl[14] wl[10] wl[9] a[4] wl[18]
+ wl[17] wl[16] wl[15] wl[19] wl[20] wl[21] wl[22] wl[23] wl[24] a[5] wl[25]
+ wl[26] wl[27] wl[28] wl[29] wl[30] wl[31] wl[32] wl[33] a[6] wl[38] wl[37]
+ wl[34] wl[35] wl[36] a[7] wl[43] wl[42] wl[41] wl[40] wl[39] wl[44] wl[45]
+ wl[46] wl[47] wl[48] a[8] wl[51] wl[52] wl[53] wl[54] wl[50] wl[49] wl[60]
+ wl[59] wl[58] wl[57] wl[56] wl[55] wl[61] wl[62] wl[63] wl[64] wl[65] wl[70]
+ wl[69] wl[68] wl[67] wl[66] wl[71] wl[72] wl[73] wl[74] wl[75] wl[76] wl[77]
+ wl[78] wl[79] wl[83] wl[80] wl[84] wl[85] wl[82] wl[81] wl[86] wl[87] wl[88]
+ wl[89] wl[90] wl[91] wl[92] wl[93] wl[94] wl[95] wl[96] wl[97] wl[98] wl[99]
+ wl[100] wl[101] wl[106] wl[105] wl[104] wl[103] wl[102] wl[107] wl[111]
+ wl[110] wl[109] wl[108] wl[112] wl[115] wl[114] wl[113] wl[119] wl[116]
+ wl[120] wl[121] wl[118] wl[117] wl[122] wl[123] wl[124] wl[125] wl[126]
+ wl[127]
X$1 vss vdd clk \$7 wl_en precharge_n columnclk we_en DP8TClockGenerator_8S1R
X$2 vss vdd a[0] a[1] mux[0] mux[1] mux[2] mux[3] \$7 DP8TLatchedDecoder_2A2R
X$3 vss vdd wl[0] a[2] wl[1] wl[2] wl[4] wl[3] wl[6] wl[5] wl[7] wl[8] a[3]
+ wl[9] wl[10] wl[12] wl[11] wl[14] wl[13] wl[15] a[4] wl[16] wl[18] wl[17]
+ wl[19] wl[20] wl[21] wl[22] wl[23] wl[24] a[5] \$7 wl[25] wl[26] wl[28]
+ wl[27] wl[30] wl[29] wl[31] a[6] wl[32] wl[33] wl[34] wl[35] wl[36] wl[38]
+ wl[37] wl[40] wl[39] a[7] wl[43] wl[42] wl[41] wl[45] wl[44] wl[47] wl[46]
+ wl[48] wl[49] wl[50] a[8] wl[52] wl[51] wl[53] wl[55] wl[54] wl[56] wl[57]
+ wl[58] wl_en wl[59] wl[60] wl[61] wl[62] wl[63] wl[65] wl[66] wl[64] wl[68]
+ wl[67] wl[69] wl[71] wl[70] wl[72] wl[73] wl[74] wl[76] wl[75] wl[77] wl[79]
+ wl[78] wl[80] wl[81] wl[82] wl[84] wl[83] wl[85] wl[87] wl[86] wl[88] wl[89]
+ wl[90] wl[92] wl[91] wl[93] wl[94] wl[95] wl[96] wl[97] wl[98] wl[99] wl[100]
+ wl[101] wl[103] wl[102] wl[104] wl[106] wl[105] wl[107] wl[109] wl[108]
+ wl[111] wl[110] wl[112] wl[113] wl[114] wl[115] wl[116] wl[117] wl[118]
+ wl[119] wl[122] wl[121] wl[120] wl[123] wl[124] wl[125] wl[126] wl[127]
+ DP8TRowDecoder_3_4B_wl1
.ENDS DP8TRowPeriphery_3_4_2_wl1

.SUBCKT DP8TRowDecoder_3_4B_wl2 vss a[0] vdd wl[126] wl[127] wl[125] wl[123]
+ wl[122] wl[124] wl[121] wl[120] wl[119] wl[118] a[1] wl[116] wl[117] wl[113]
+ wl[114] wl[115] wl[111] wl[112] a[2] wl[109] wl[110] wl[108] wl[106] wl[105]
+ wl[107] clk wl[104] wl[103] a[3] wl[101] wl[100] wl[102] wl[98] wl[99] wl[97]
+ wl[96] a[4] wl[94] wl[93] wl[95] wl[91] wl[92] wl[90] wl[88] wl[89] wl[87]
+ wl[86] wl[85] a[5] wl[84] wl[83] wl[82] wl[81] wl[80] wl[78] wl[77] wl[79]
+ a[6] wl[76] wl[75] wl[74] wl[73] wl[72] wl[70] wl[69] wl[71] wl_en wl[68]
+ wl[67] wl[66] wl[64] wl[65] wl[62] wl[63] wl[61] wl[60] wl[59] wl[58] wl[57]
+ wl[56] wl[54] wl[53] wl[55] wl[52] wl[51] wl[50] wl[48] wl[49] wl[46] wl[47]
+ wl[45] wl[44] wl[43] wl[42] wl[41] wl[40] wl[38] wl[37] wl[39] wl[36] wl[35]
+ wl[34] wl[32] wl[33] wl[30] wl[31] wl[29] wl[28] wl[27] wl[26] wl[24] wl[25]
+ wl[20] wl[21] wl[22] wl[23] wl[19] wl[18] wl[16] wl[17] wl[14] wl[15] wl[13]
+ wl[12] wl[11] wl[10] wl[9] wl[8] wl[7] wl[6] wl[4] wl[5] wl[2] wl[3] wl[0]
+ wl[1]
X$1 vss vdd \$5 \$14 \$18 \$12 \$28 \$19 \$9 \$40 \$13 \$49 \$6 \$10 \$66 \$74
+ \$88 \$97 \$109 \$120 \$131 \$138 \$152 \$159 \$169 \$180 clk a[0] a[1] a[2]
+ a[3] a[4] a[5] a[6] DP8TRowPredecoders_3_4B_wl2
X$3 vss \$18 \$5 wl[120] vdd wl[121] \$19 \$12 wl[122] wl_en wl[123] \$13 \$9
+ wl[124] wl[125] \$10 \$6 wl[126] \$14 wl[127]
+ DP8TRowDecoderDriverPage_2PD8R_wl2
X$4 vss \$18 \$5 wl[112] vdd wl[113] \$19 \$12 wl[114] wl_en wl[115] \$13 \$9
+ wl[116] wl[117] \$10 \$6 wl[118] \$28 wl[119]
+ DP8TRowDecoderDriverPage_2PD8R_wl2
X$6 vss \$18 \$5 wl[104] vdd wl[105] \$19 \$12 wl[106] wl_en wl[107] \$13 \$9
+ wl[108] wl[109] \$10 \$6 wl[110] \$40 wl[111]
+ DP8TRowDecoderDriverPage_2PD8R_wl2
X$7 vss \$18 \$5 wl[96] vdd wl[97] \$19 \$12 wl[98] wl_en wl[99] \$13 \$9
+ wl[100] wl[101] \$10 \$6 wl[102] \$49 wl[103]
+ DP8TRowDecoderDriverPage_2PD8R_wl2
X$9 vss \$18 \$5 wl[88] vdd wl[89] \$19 \$12 wl[90] wl_en wl[91] \$13 \$9
+ wl[92] wl[93] \$10 \$6 wl[94] \$66 wl[95] DP8TRowDecoderDriverPage_2PD8R_wl2
X$10 vss \$18 \$5 wl[80] vdd wl[81] \$19 \$12 wl[82] wl_en wl[83] \$13 \$9
+ wl[84] wl[85] \$10 \$6 wl[86] \$74 wl[87] DP8TRowDecoderDriverPage_2PD8R_wl2
X$12 vss \$18 \$5 wl[72] vdd wl[73] \$19 \$12 wl[74] wl_en wl[75] \$13 \$9
+ wl[76] wl[77] \$10 \$6 wl[78] \$88 wl[79] DP8TRowDecoderDriverPage_2PD8R_wl2
X$13 vss \$18 \$5 wl[64] vdd wl[65] \$19 \$12 wl[66] wl_en wl[67] \$13 \$9
+ wl[68] wl[69] \$10 \$6 wl[70] \$97 wl[71] DP8TRowDecoderDriverPage_2PD8R_wl2
X$15 vss \$18 \$5 wl[56] vdd wl[57] \$19 \$12 wl[58] wl_en wl[59] \$13 \$9
+ wl[60] wl[61] \$10 \$6 wl[62] \$109 wl[63] DP8TRowDecoderDriverPage_2PD8R_wl2
X$16 vss \$18 \$5 wl[48] vdd wl[49] \$19 \$12 wl[50] wl_en wl[51] \$13 \$9
+ wl[52] wl[53] \$10 \$6 wl[54] \$120 wl[55] DP8TRowDecoderDriverPage_2PD8R_wl2
X$18 vss \$18 \$5 wl[40] vdd wl[41] \$19 \$12 wl[42] wl_en wl[43] \$13 \$9
+ wl[44] wl[45] \$10 \$6 wl[46] \$131 wl[47] DP8TRowDecoderDriverPage_2PD8R_wl2
X$19 vss \$18 \$5 wl[32] vdd wl[33] \$19 \$12 wl[34] wl_en wl[35] \$13 \$9
+ wl[36] wl[37] \$10 \$6 wl[38] \$138 wl[39] DP8TRowDecoderDriverPage_2PD8R_wl2
X$21 vss \$18 \$5 wl[24] vdd wl[25] \$19 \$12 wl[26] wl_en wl[27] \$13 \$9
+ wl[28] wl[29] \$10 \$6 wl[30] \$152 wl[31] DP8TRowDecoderDriverPage_2PD8R_wl2
X$22 vss \$18 \$5 wl[16] vdd wl[17] \$19 \$12 wl[18] wl_en wl[19] \$13 \$9
+ wl[20] wl[21] \$10 \$6 wl[22] \$159 wl[23] DP8TRowDecoderDriverPage_2PD8R_wl2
X$24 vss \$18 \$5 wl[8] vdd wl[9] \$19 \$12 wl[10] wl_en wl[11] \$13 \$9 wl[12]
+ wl[13] \$10 \$6 wl[14] \$169 wl[15] DP8TRowDecoderDriverPage_2PD8R_wl2
X$25 vss \$18 \$5 wl[0] vdd wl[1] \$19 \$12 wl[2] wl_en wl[3] \$13 \$9 wl[4]
+ wl[5] \$10 \$6 wl[6] \$180 wl[7] DP8TRowDecoderDriverPage_2PD8R_wl2
.ENDS DP8TRowDecoder_3_4B_wl2

.SUBCKT DP8TColumn_128R8B4M vss d1[0] q1[0] d1[1] q1[1] d1[2] q1[2] d1[3] q1[3]
+ d1[4] q1[4] d1[5] q1[5] d1[6] q1[6] d1[7] q1[7] we1 clk1 we_en1 vdd mux1[0]
+ wl2[17] wl1[2] wl1[5] wl2[2] wl1[12] wl2[0] wl2[1] wl1[1] wl1[0] wl1[8]
+ wl1[18] wl2[12] wl2[18] wl2[11] wl1[19] wl1[11] wl1[10] wl2[10] wl2[9] wl1[9]
+ wl1[3] wl2[8] wl2[7] wl1[7] wl1[6] wl2[6] wl2[5] wl2[19] wl1[4] wl2[4] wl2[3]
+ wl1[17] wl2[14] wl2[13] precharge1_n mux1[3] mux1[2] mux1[1] wl1[14] wl1[13]
+ wl1[15] wl2[15] wl2[16] wl1[16] wl1[25] wl2[20] wl1[24] wl2[25] wl2[26]
+ wl2[24] wl1[26] wl1[27] wl2[27] wl2[23] wl2[28] wl1[28] wl1[22] wl2[22]
+ wl2[21] wl1[21] wl1[20] wl1[23] wl1[35] wl1[34] wl2[34] wl2[33] wl1[33]
+ wl1[32] wl1[29] wl2[32] wl2[36] wl1[36] wl2[29] wl2[30] wl2[31] wl1[30]
+ wl1[31] wl2[35] wl2[45] wl1[43] wl1[40] wl1[45] wl1[41] wl1[44] wl2[41]
+ wl2[44] wl2[42] wl2[43] wl1[42] wl2[39] wl1[39] wl1[38] wl2[38] wl2[37]
+ wl1[37] wl2[40] wl2[49] wl2[50] wl1[49] wl1[50] wl1[51] wl2[51] wl1[48]
+ wl2[52] wl2[53] wl1[52] wl2[48] wl1[53] wl2[46] wl1[46] wl2[47] wl1[47]
+ wl1[62] wl2[60] wl2[62] wl2[57] wl2[61] wl2[58] wl1[61] wl1[58] wl1[59]
+ wl1[60] wl2[59] wl1[56] wl2[56] wl2[55] wl1[55] wl1[54] wl2[54] wl1[57]
+ wl1[66] wl1[67] wl2[66] wl2[67] wl2[68] wl1[68] wl2[65] wl1[69] wl1[70]
+ wl2[69] wl1[65] wl2[70] wl2[64] wl1[63] wl2[63] wl1[64] wl2[79] wl1[77]
+ wl1[79] wl1[74] wl1[78] wl1[75] wl2[78] wl2[75] wl2[76] wl2[77] wl1[76]
+ wl2[73] wl1[73] wl1[72] wl2[72] wl2[71] wl1[71] wl2[74] wl2[83] wl2[84]
+ wl1[83] wl1[84] wl1[85] wl2[85] wl1[82] wl2[86] wl2[87] wl1[86] wl2[82]
+ wl1[87] wl1[81] wl1[80] wl2[81] wl2[80] wl1[94] wl2[91] wl2[92] wl1[92]
+ wl1[93] wl2[95] wl2[93] wl1[95] wl2[94] wl1[90] wl2[90] wl2[89] wl1[89]
+ wl1[88] wl2[88] wl1[91] wl1[100] wl1[101] wl2[100] wl2[101] wl2[102] wl1[102]
+ wl2[99] wl1[103] wl1[104] wl2[103] wl1[99] wl2[104] wl2[98] wl2[96] wl1[96]
+ wl2[97] wl1[98] wl1[97] wl1[112] wl2[111] wl1[108] wl1[109] wl2[109] wl2[112]
+ wl2[110] wl1[110] wl1[111] wl2[107] wl1[107] wl1[106] wl2[106] wl2[105]
+ wl1[105] wl2[108] wl2[117] wl2[118] wl1[117] wl1[118] wl1[119] wl2[119]
+ wl1[116] wl2[120] wl2[121] wl1[120] wl2[116] wl1[121] wl1[115] wl1[113]
+ wl2[113] wl1[114] wl2[115] wl2[114] wl1[123] wl2[123] wl1[122] wl2[122]
+ wl2[124] wl1[124] wl1[125] wl2[125] wl2[127] wl1[127] wl1[126] wl2[126]
+ we_en2 clk2 we2 q2[0] d2[0] q2[1] d2[1] q2[2] d2[2] q2[3] d2[3] mux2[3]
+ mux2[2] precharge2_n mux2[1] mux2[0] q2[4] d2[4] q2[5] d2[5] q2[6] d2[6]
+ q2[7] d2[7]
X$1 vss we1 d1[0] d1[1] vdd d1[2] d1[3] d1[4] d1[5] d1[6] d1[7] clk1 we_en1
+ q1[0] q1[1] q1[2] q1[3] q1[4] q1[5] q1[6] q1[7] bl1[0] bl1_n[0] bl1_n[1]
+ bl1[1] bl1[2] bl1_n[2] bl1_n[3] bl1[3] bl1[4] bl1_n[4] bl1_n[5] bl1[5] bl1[6]
+ bl1_n[6] bl1_n[7] bl1[7] bl1[8] bl1_n[8] bl1_n[9] bl1[9] bl1[10] bl1_n[10]
+ bl1_n[11] bl1[11] bl1[12] bl1_n[12] bl1_n[13] bl1[13] bl1[14] bl1_n[14]
+ bl1_n[15] bl1[15] mux1[0] bl1[16] bl1_n[16] bl1_n[17] bl1[17] bl1[18]
+ bl1_n[18] bl1_n[19] bl1[19] bl1[20] bl1_n[20] bl1_n[21] bl1[21] bl1[22]
+ bl1_n[22] bl1_n[23] bl1[23] bl1[24] bl1_n[24] bl1_n[25] bl1[25] bl1[26]
+ bl1_n[26] bl1_n[27] bl1[27] bl1[28] bl1_n[28] bl1_n[29] bl1[29] bl1[30]
+ bl1_n[30] bl1_n[31] bl1[31] mux1[2] mux1[1] precharge1_n mux1[3] vdd
+ DP8TColumnPeriphery_8B4M_bl1
X$2 vss wl2[13] wl1[13] wl2[14] wl1[15] wl1[14] wl1[16] wl2[21] wl2[15] wl2[16]
+ vdd wl2[32] wl2[28] wl1[28] wl1[29] wl2[29] wl2[30] wl1[30] wl1[31] wl2[31]
+ wl2[27] wl1[32] wl1[33] wl2[33] wl2[34] wl1[34] wl1[35] wl2[35] wl2[36]
+ wl1[36] wl1[37] wl1[22] wl2[17] wl2[18] wl1[18] wl1[19] wl2[19] wl2[20]
+ wl1[20] wl1[21] wl1[9] wl2[22] wl1[17] wl1[23] wl2[23] wl2[24] wl1[24]
+ wl1[25] wl2[25] wl2[26] wl1[26] wl1[27] wl2[12] wl1[12] wl2[0] wl1[0] wl1[1]
+ wl2[1] wl2[2] wl1[2] wl1[3] wl2[3] wl2[4] wl1[4] wl1[5] wl2[6] wl2[11]
+ wl1[11] wl1[10] wl2[10] wl2[9] wl1[8] wl2[8] wl2[7] wl1[7] wl1[6] wl2[5]
+ bl1[0] bl2[0] bl1_n[0] bl2_n[0] bl2_n[1] bl1_n[1] bl2[1] bl1[1] bl1[2] bl2[2]
+ bl1_n[2] bl2_n[2] bl2_n[3] bl1_n[3] bl2[3] bl1[3] bl1[4] bl2[4] bl1_n[4]
+ bl2_n[4] bl2_n[5] bl1_n[5] bl2[5] bl1[5] bl1[6] bl2[6] bl1_n[6] bl2_n[6]
+ bl2_n[7] bl1_n[7] bl2[7] bl1[7] bl1[8] bl2[8] bl1_n[8] bl2_n[8] bl2_n[9]
+ bl1_n[9] bl2[9] bl1[9] bl1[10] bl2[10] bl1_n[10] bl2_n[10] bl2_n[11]
+ bl1_n[11] bl2[11] bl1[11] bl1[12] bl2[12] bl1_n[12] bl2_n[12] bl2_n[13]
+ bl1_n[13] bl2[13] bl1[13] bl1[14] bl2[14] bl1_n[14] bl2_n[14] bl2_n[15]
+ bl1_n[15] bl2[15] bl1[15] wl1[46] wl2[38] wl2[53] wl2[37] wl2[54] wl1[53]
+ wl1[54] wl1[55] wl2[55] wl2[56] wl1[56] wl1[57] wl2[57] wl2[58] wl1[58]
+ wl1[59] wl2[59] wl2[60] wl1[60] wl1[61] wl2[61] wl2[62] wl1[62] wl1[63]
+ wl2[63] wl2[46] wl2[43] wl2[49] wl2[42] wl1[49] wl1[42] wl1[48] wl1[43]
+ wl2[45] wl2[48] wl1[52] wl1[38] wl2[44] wl1[44] wl1[47] wl2[47] wl1[45]
+ wl1[41] wl2[51] wl2[40] wl1[51] wl1[40] wl2[39] wl1[50] wl2[52] wl1[39]
+ wl2[50] wl2[41] bl1[16] bl2[16] bl1_n[16] bl2_n[16] bl2_n[17] bl1_n[17]
+ bl2[17] bl1[17] bl1[18] bl2[18] bl1_n[18] bl2_n[18] bl2_n[19] bl1_n[19]
+ bl2[19] bl1[19] bl1[20] bl2[20] bl1_n[20] bl2_n[20] bl2_n[21] bl1_n[21]
+ bl2[21] bl1[21] bl1[22] bl2[22] bl1_n[22] bl2_n[22] bl2_n[23] bl1_n[23]
+ bl2[23] bl1[23] bl1[24] bl2[24] bl1_n[24] bl2_n[24] bl2_n[25] bl1_n[25]
+ bl2[25] bl1[25] bl1[26] bl2[26] bl1_n[26] bl2_n[26] bl2_n[27] bl1_n[27]
+ bl2[27] bl1[27] bl1[28] bl2[28] bl1_n[28] bl2_n[28] bl2_n[29] bl1_n[29]
+ bl2[29] bl1[29] bl1[30] bl2[30] bl1_n[30] bl2_n[30] bl2_n[31] bl1_n[31]
+ bl2[31] bl1[31] wl2[115] wl2[120] wl1[87] wl2[119] wl1[119] wl1[118] wl2[87]
+ wl2[118] wl2[117] wl1[117] wl2[88] wl1[116] wl2[116] wl1[120] wl1[88]
+ wl1[115] wl1[114] wl1[89] wl2[114] wl2[113] wl1[113] wl2[89] wl1[112]
+ wl1[124] wl2[84] wl2[127] wl1[84] wl1[127] wl1[126] wl2[126] wl1[85] wl2[125]
+ wl1[125] wl2[112] wl2[85] wl2[124] wl2[123] wl1[123] wl2[86] wl1[122]
+ wl2[122] wl2[121] wl1[86] wl1[121] wl2[99] wl2[103] wl1[93] wl1[103] wl1[102]
+ wl2[102] wl2[93] wl2[101] wl1[101] wl1[100] wl2[94] wl2[100] wl2[104] wl1[99]
+ wl1[94] wl1[98] wl2[98] wl1[95] wl2[97] wl2[95] wl1[97] wl1[96] wl1[108]
+ wl2[90] wl2[111] wl1[111] wl1[90] wl1[110] wl2[110] wl2[109] wl1[91] wl1[109]
+ wl2[96] wl2[108] wl2[91] wl2[107] wl1[107] wl1[106] wl2[92] wl2[106] wl2[105]
+ wl1[105] wl1[92] wl1[104] wl1[68] wl2[73] wl1[73] wl1[72] wl2[72] wl2[71]
+ wl1[71] wl1[70] wl2[70] wl2[69] wl1[69] wl1[65] wl2[68] wl2[67] wl1[67]
+ wl1[66] wl2[66] wl2[65] wl1[64] wl2[64] wl2[83] wl1[74] wl1[83] wl1[82]
+ wl2[82] wl2[81] wl1[81] wl1[80] wl2[80] wl2[79] wl1[78] wl2[74] wl1[75]
+ wl2[75] wl2[76] wl1[79] wl1[76] wl2[78] wl1[77] wl2[77] DP8TArray_128X32BC
X$3 vss we2 d2[7] d2[6] vdd d2[5] d2[4] d2[3] d2[2] d2[1] d2[0] clk2 we_en2
+ q2[7] q2[6] q2[5] q2[4] q2[3] q2[2] q2[1] q2[0] bl2[31] bl2_n[31] bl2_n[30]
+ bl2[30] bl2[29] bl2_n[29] bl2_n[28] bl2[28] bl2[27] bl2_n[27] bl2_n[26]
+ bl2[26] bl2[25] bl2_n[25] bl2_n[24] bl2[24] bl2[23] bl2_n[23] bl2_n[22]
+ bl2[22] bl2[21] bl2_n[21] bl2_n[20] bl2[20] bl2[19] bl2_n[19] bl2_n[18]
+ bl2[18] bl2[17] bl2_n[17] bl2_n[16] bl2[16] mux2[0] bl2[15] bl2_n[15]
+ bl2_n[14] bl2[14] bl2[13] bl2_n[13] bl2_n[12] bl2[12] bl2[11] bl2_n[11]
+ bl2_n[10] bl2[10] bl2[9] bl2_n[9] bl2_n[8] bl2[8] bl2[7] bl2_n[7] bl2_n[6]
+ bl2[6] bl2[5] bl2_n[5] bl2_n[4] bl2[4] bl2[3] bl2_n[3] bl2_n[2] bl2[2] bl2[1]
+ bl2_n[1] bl2_n[0] bl2[0] mux2[3] precharge2_n mux2[1] mux2[2] vdd
+ DP8TColumnPeriphery_8B4M_bl2
.ENDS DP8TColumn_128R8B4M

.SUBCKT DP8TClockGenerator_8S1R vss vdd clk decodeclk wl_en precharge_n
+ columnclk we_en
X$1 vdd vss \$8 wl_en buf_x1
X$2 vdd vss clk decodeclk buf_x1
X$3 vss vdd precharge_n \$11 inv_x1
X$4 vdd vss clk columnclk buf_x1
X$5 vss vdd \$8 \$11 clk DP8TNonOverlapClock_8S1R
X$6 vdd vss \$8 we_en buf_x1
.ENDS DP8TClockGenerator_8S1R

.SUBCKT DP8TLatchedDecoder_2A2R vss vdd a[0] a[1] line[0] line[1] line[2]
+ line[3] clk
X$1 vss a[0] \$12 clk vdd DP8TDec_dff_x1
X$2 vss a[1] \$13 clk vdd DP8TDec_dff_x1
X$3 vss vdd \$14 \$12 DP8TDec_inv_x1
X$4 vss vdd \$14 \$16 \$15 DP8TDec_nand2_x0
X$5 vss vdd line[0] \$16 DP8TDec_inv_x2
X$6 vss vdd \$12 \$17 \$15 DP8TDec_nand2_x0
X$7 vss vdd line[1] \$17 DP8TDec_inv_x2
X$8 vss vdd \$14 \$18 \$13 DP8TDec_nand2_x0
X$9 vss vdd \$15 \$13 DP8TDec_inv_x1
X$10 vss vdd line[2] \$18 DP8TDec_inv_x2
X$11 vss vdd \$12 \$19 \$13 DP8TDec_nand2_x0
X$12 vss vdd line[3] \$19 DP8TDec_inv_x2
.ENDS DP8TLatchedDecoder_2A2R

.SUBCKT DP8TRowDecoder_3_4B_wl1 vss vdd wl[0] a[0] wl[1] wl[2] wl[4] wl[3]
+ wl[6] wl[5] wl[7] wl[8] a[1] wl[9] wl[10] wl[12] wl[11] wl[14] wl[13] wl[15]
+ a[2] wl[16] wl[18] wl[17] wl[19] wl[20] wl[21] wl[22] wl[23] wl[24] a[3] clk
+ wl[25] wl[26] wl[28] wl[27] wl[30] wl[29] wl[31] a[4] wl[32] wl[33] wl[34]
+ wl[35] wl[36] wl[38] wl[37] wl[40] wl[39] a[5] wl[43] wl[42] wl[41] wl[45]
+ wl[44] wl[47] wl[46] wl[48] wl[49] wl[50] a[6] wl[52] wl[51] wl[53] wl[55]
+ wl[54] wl[56] wl[57] wl[58] wl_en wl[59] wl[60] wl[61] wl[62] wl[63] wl[65]
+ wl[66] wl[64] wl[68] wl[67] wl[69] wl[71] wl[70] wl[72] wl[73] wl[74] wl[76]
+ wl[75] wl[77] wl[79] wl[78] wl[80] wl[81] wl[82] wl[84] wl[83] wl[85] wl[87]
+ wl[86] wl[88] wl[89] wl[90] wl[92] wl[91] wl[93] wl[94] wl[95] wl[96] wl[97]
+ wl[98] wl[99] wl[100] wl[101] wl[103] wl[102] wl[104] wl[106] wl[105] wl[107]
+ wl[109] wl[108] wl[111] wl[110] wl[112] wl[113] wl[114] wl[115] wl[116]
+ wl[117] wl[118] wl[119] wl[122] wl[121] wl[120] wl[123] wl[124] wl[125]
+ wl[126] wl[127]
X$2 vss vdd \$6 \$17 \$7 \$11 \$29 \$8 \$15 \$40 \$12 \$51 \$20 \$16 \$65 \$72
+ \$88 \$97 \$109 \$120 \$131 \$138 \$152 \$155 \$169 \$180 clk a[0] a[1] a[2]
+ a[3] a[4] a[5] a[6] DP8TRowPredecoders_3_4B_wl1
X$3 vss wl[0] \$7 \$6 wl[1] vdd wl[2] \$8 \$11 wl_en wl[3] wl[4] \$12 \$15
+ wl[5] wl[6] \$16 \$20 \$17 wl[7] DP8TRowDecoderDriverPage_2PD8R_wl1
X$4 vss wl[8] \$7 \$6 wl[9] vdd wl[10] \$8 \$11 wl_en wl[11] wl[12] \$12 \$15
+ wl[13] wl[14] \$16 \$20 \$29 wl[15] DP8TRowDecoderDriverPage_2PD8R_wl1
X$6 vss wl[16] \$7 \$6 wl[17] vdd wl[18] \$8 \$11 wl_en wl[19] wl[20] \$12 \$15
+ wl[21] wl[22] \$16 \$20 \$40 wl[23] DP8TRowDecoderDriverPage_2PD8R_wl1
X$7 vss wl[24] \$7 \$6 wl[25] vdd wl[26] \$8 \$11 wl_en wl[27] wl[28] \$12 \$15
+ wl[29] wl[30] \$16 \$20 \$51 wl[31] DP8TRowDecoderDriverPage_2PD8R_wl1
X$9 vss wl[32] \$7 \$6 wl[33] vdd wl[34] \$8 \$11 wl_en wl[35] wl[36] \$12 \$15
+ wl[37] wl[38] \$16 \$20 \$65 wl[39] DP8TRowDecoderDriverPage_2PD8R_wl1
X$10 vss wl[40] \$7 \$6 wl[41] vdd wl[42] \$8 \$11 wl_en wl[43] wl[44] \$12
+ \$15 wl[45] wl[46] \$16 \$20 \$72 wl[47] DP8TRowDecoderDriverPage_2PD8R_wl1
X$12 vss wl[48] \$7 \$6 wl[49] vdd wl[50] \$8 \$11 wl_en wl[51] wl[52] \$12
+ \$15 wl[53] wl[54] \$16 \$20 \$88 wl[55] DP8TRowDecoderDriverPage_2PD8R_wl1
X$13 vss wl[56] \$7 \$6 wl[57] vdd wl[58] \$8 \$11 wl_en wl[59] wl[60] \$12
+ \$15 wl[61] wl[62] \$16 \$20 \$97 wl[63] DP8TRowDecoderDriverPage_2PD8R_wl1
X$15 vss wl[64] \$7 \$6 wl[65] vdd wl[66] \$8 \$11 wl_en wl[67] wl[68] \$12
+ \$15 wl[69] wl[70] \$16 \$20 \$109 wl[71] DP8TRowDecoderDriverPage_2PD8R_wl1
X$16 vss wl[72] \$7 \$6 wl[73] vdd wl[74] \$8 \$11 wl_en wl[75] wl[76] \$12
+ \$15 wl[77] wl[78] \$16 \$20 \$120 wl[79] DP8TRowDecoderDriverPage_2PD8R_wl1
X$18 vss wl[80] \$7 \$6 wl[81] vdd wl[82] \$8 \$11 wl_en wl[83] wl[84] \$12
+ \$15 wl[85] wl[86] \$16 \$20 \$131 wl[87] DP8TRowDecoderDriverPage_2PD8R_wl1
X$19 vss wl[88] \$7 \$6 wl[89] vdd wl[90] \$8 \$11 wl_en wl[91] wl[92] \$12
+ \$15 wl[93] wl[94] \$16 \$20 \$138 wl[95] DP8TRowDecoderDriverPage_2PD8R_wl1
X$21 vss wl[96] \$7 \$6 wl[97] vdd wl[98] \$8 \$11 wl_en wl[99] wl[100] \$12
+ \$15 wl[101] wl[102] \$16 \$20 \$152 wl[103]
+ DP8TRowDecoderDriverPage_2PD8R_wl1
X$22 vss wl[104] \$7 \$6 wl[105] vdd wl[106] \$8 \$11 wl_en wl[107] wl[108]
+ \$12 \$15 wl[109] wl[110] \$16 \$20 \$155 wl[111]
+ DP8TRowDecoderDriverPage_2PD8R_wl1
X$24 vss wl[112] \$7 \$6 wl[113] vdd wl[114] \$8 \$11 wl_en wl[115] wl[116]
+ \$12 \$15 wl[117] wl[118] \$16 \$20 \$169 wl[119]
+ DP8TRowDecoderDriverPage_2PD8R_wl1
X$25 vss wl[120] \$7 \$6 wl[121] vdd wl[122] \$8 \$11 wl_en wl[123] wl[124]
+ \$12 \$15 wl[125] wl[126] \$16 \$20 \$180 wl[127]
+ DP8TRowDecoderDriverPage_2PD8R_wl1
.ENDS DP8TRowDecoder_3_4B_wl1

.SUBCKT DP8TRowDecoderDriverPage_2PD8R_wl2 vss pd[0][1] pd[0][0] wl[0] vdd
+ wl[1] pd[0][3] pd[0][2] wl[2] wl_en wl[3] pd[0][5] pd[0][4] wl[4] wl[5]
+ pd[0][7] pd[0][6] wl[6] page wl[7]
X$1 wl[1] vss \$10 vdd vss vdd DP8TWLDrive_26LN100WN26LP200WP_wl2
X$2 wl[0] vss \$3 vdd vss vdd DP8TWLDrive_26LN100WN26LP200WP_wl2
X$3 wl[2] vss \$8 vdd vss vdd DP8TWLDrive_26LN100WN26LP200WP_wl2
X$4 wl[3] vss \$17 vdd vss vdd DP8TWLDrive_26LN100WN26LP200WP_wl2
X$5 wl[4] vss \$19 vdd vss vdd DP8TWLDrive_26LN100WN26LP200WP_wl2
X$6 wl[5] vss \$23 vdd vss vdd DP8TWLDrive_26LN100WN26LP200WP_wl2
X$7 wl[6] vss \$24 vdd vss vdd DP8TWLDrive_26LN100WN26LP200WP_wl2
X$8 wl[7] vss \$31 vdd vss vdd DP8TWLDrive_26LN100WN26LP200WP_wl2
X$9 vss vdd \$8 wl_en pd[0][2] page \$17 pd[0][3] DP8TRowDecoderNand3X2
X$10 vss vdd \$3 wl_en pd[0][0] page \$10 pd[0][1] DP8TRowDecoderNand3X2
X$11 vss vdd \$19 wl_en pd[0][4] page \$23 pd[0][5] DP8TRowDecoderNand3X2
X$12 vss vdd \$24 wl_en pd[0][6] page \$31 pd[0][7] DP8TRowDecoderNand3X2
.ENDS DP8TRowDecoderDriverPage_2PD8R_wl2

.SUBCKT DP8TRowPredecoders_3_4B_wl2 vss vdd pd[0][0] page[15] pd[0][1] pd[0][2]
+ page[14] pd[0][3] pd[0][4] page[13] pd[0][5] page[12] pd[0][6] pd[0][7]
+ page[11] page[10] page[9] page[8] page[7] page[6] page[5] page[4] page[3]
+ page[2] page[1] page[0] clk a[0] a[1] a[2] a[3] a[4] a[5] a[6]
X$1 vss a[0] \$34 clk vdd DP8TDec_dff_x1
X$2 vss vdd \$27 \$34 DP8TDec_inv_x1
X$3 vdd vss \$27 \$28 \$29 pd[0][0] DP8TDec_and3_x1
X$4 vdd vss \$30 \$31 \$32 \$33 page[15] DP8TDec_and4_x1
X$5 vdd vss \$34 \$28 \$29 pd[0][1] DP8TDec_and3_x1
X$6 vss a[1] \$35 clk vdd DP8TDec_dff_x1
X$7 vdd vss \$27 \$35 \$29 pd[0][2] DP8TDec_and3_x1
X$8 vss vdd \$28 \$35 DP8TDec_inv_x1
X$9 vdd vss \$36 \$31 \$32 \$33 page[14] DP8TDec_and4_x1
X$10 vdd vss \$34 \$35 \$29 pd[0][3] DP8TDec_and3_x1
X$11 vss a[2] \$37 clk vdd DP8TDec_dff_x1
X$12 vdd vss \$27 \$28 \$37 pd[0][4] DP8TDec_and3_x1
X$13 vss vdd \$29 \$37 DP8TDec_inv_x1
X$14 vdd vss \$30 \$38 \$32 \$33 page[13] DP8TDec_and4_x1
X$15 vdd vss \$34 \$28 \$37 pd[0][5] DP8TDec_and3_x1
X$16 vss a[3] \$30 clk vdd DP8TDec_dff_x1
X$17 vdd vss \$36 \$38 \$32 \$33 page[12] DP8TDec_and4_x1
X$18 vss vdd \$36 \$30 DP8TDec_inv_x1
X$19 vdd vss \$27 \$35 \$37 pd[0][6] DP8TDec_and3_x1
X$20 vdd vss \$34 \$35 \$37 pd[0][7] DP8TDec_and3_x1
X$21 vss a[4] \$31 clk vdd DP8TDec_dff_x1
X$23 vss vdd \$38 \$31 DP8TDec_inv_x1
X$24 vdd vss \$30 \$31 \$39 \$33 page[11] DP8TDec_and4_x1
X$26 vss a[5] \$32 clk vdd DP8TDec_dff_x1
X$27 vdd vss \$36 \$31 \$39 \$33 page[10] DP8TDec_and4_x1
X$28 vss vdd \$39 \$32 DP8TDec_inv_x1
X$31 vss a[6] \$33 clk vdd DP8TDec_dff_x1
X$32 vdd vss \$30 \$38 \$39 \$33 page[9] DP8TDec_and4_x1
X$33 vss vdd \$40 \$33 DP8TDec_inv_x1
X$37 vdd vss \$36 \$38 \$39 \$33 page[8] DP8TDec_and4_x1
X$43 vdd vss \$30 \$31 \$32 \$40 page[7] DP8TDec_and4_x1
X$49 vdd vss \$36 \$31 \$32 \$40 page[6] DP8TDec_and4_x1
X$55 vdd vss \$30 \$38 \$32 \$40 page[5] DP8TDec_and4_x1
X$59 vdd vss \$36 \$38 \$32 \$40 page[4] DP8TDec_and4_x1
X$67 vdd vss \$30 \$31 \$39 \$40 page[3] DP8TDec_and4_x1
X$71 vdd vss \$36 \$31 \$39 \$40 page[2] DP8TDec_and4_x1
X$77 vdd vss \$30 \$38 \$39 \$40 page[1] DP8TDec_and4_x1
X$83 vdd vss \$36 \$38 \$39 \$40 page[0] DP8TDec_and4_x1
.ENDS DP8TRowPredecoders_3_4B_wl2

.SUBCKT DP8TColumnPeriphery_8B4M_bl2 vss we d[0] d[1] vdd d[2] d[3] d[4] d[5]
+ d[6] d[7] clk we_en q[0] q[1] q[2] q[3] q[4] q[5] q[6] q[7] bl[0] bl_n[0]
+ bl_n[1] bl[1] bl[2] bl_n[2] bl_n[3] bl[3] bl[4] bl_n[4] bl_n[5] bl[5] bl[6]
+ bl_n[6] bl_n[7] bl[7] bl[8] bl_n[8] bl_n[9] bl[9] bl[10] bl_n[10] bl_n[11]
+ bl[11] bl[12] bl_n[12] bl_n[13] bl[13] bl[14] bl_n[14] bl_n[15] bl[15] mux[0]
+ bl[16] bl_n[16] bl_n[17] bl[17] bl[18] bl_n[18] bl_n[19] bl[19] bl[20]
+ bl_n[20] bl_n[21] bl[21] bl[22] bl_n[22] bl_n[23] bl[23] bl[24] bl_n[24]
+ bl_n[25] bl[25] bl[26] bl_n[26] bl_n[27] bl[27] bl[28] bl_n[28] bl_n[29]
+ bl[29] bl[30] bl_n[30] bl_n[31] bl[31] mux[3] precharge_n mux[1] mux[2] \$I302
X$1 \$101 bl[4] bl_n[4] \$99 bl_n[5] bl[5] bl[6] bl_n[6] bl_n[7] bl[7] mux[0]
+ vss mux[1] mux[2] mux[3] DP8TColMux_4C_bl2
X$2 \$93 bl[0] bl_n[0] \$97 bl_n[1] bl[1] bl[2] bl_n[2] bl_n[3] bl[3] mux[0]
+ vss mux[1] mux[2] mux[3] DP8TColMux_4C_bl2
X$3 precharge_n vdd bl[0] bl_n[0] \$I302 DP8TPrecharge_bl2
X$4 precharge_n vdd bl[1] bl_n[1] \$I302 DP8TPrecharge_bl2
X$5 precharge_n vdd bl[2] bl_n[2] \$I302 DP8TPrecharge_bl2
X$6 precharge_n vdd bl[3] bl_n[3] \$I302 DP8TPrecharge_bl2
X$7 precharge_n vdd bl[4] bl_n[4] \$I302 DP8TPrecharge_bl2
X$8 \$106 bl[8] bl_n[8] \$107 bl_n[9] bl[9] bl[10] bl_n[10] bl_n[11] bl[11]
+ mux[0] vss mux[1] mux[2] mux[3] DP8TColMux_4C_bl2
X$9 precharge_n vdd bl[5] bl_n[5] \$I302 DP8TPrecharge_bl2
X$10 precharge_n vdd bl[6] bl_n[6] \$I302 DP8TPrecharge_bl2
X$11 precharge_n vdd bl[7] bl_n[7] \$I302 DP8TPrecharge_bl2
X$12 precharge_n vdd bl[8] bl_n[8] \$I302 DP8TPrecharge_bl2
X$13 \$104 bl[12] bl_n[12] \$105 bl_n[13] bl[13] bl[14] bl_n[14] bl_n[15]
+ bl[15] mux[0] vss mux[1] mux[2] mux[3] DP8TColMux_4C_bl2
X$14 precharge_n vdd bl[9] bl_n[9] \$I302 DP8TPrecharge_bl2
X$15 precharge_n vdd bl[10] bl_n[10] \$I302 DP8TPrecharge_bl2
X$16 precharge_n vdd bl[11] bl_n[11] \$I302 DP8TPrecharge_bl2
X$17 precharge_n vdd bl[12] bl_n[12] \$I302 DP8TPrecharge_bl2
X$18 \$102 bl[16] bl_n[16] \$103 bl_n[17] bl[17] bl[18] bl_n[18] bl_n[19]
+ bl[19] mux[0] vss mux[1] mux[2] mux[3] DP8TColMux_4C_bl2
X$19 precharge_n vdd bl[13] bl_n[13] \$I302 DP8TPrecharge_bl2
X$20 precharge_n vdd bl[14] bl_n[14] \$I302 DP8TPrecharge_bl2
X$21 precharge_n vdd bl[15] bl_n[15] \$I302 DP8TPrecharge_bl2
X$22 precharge_n vdd bl[16] bl_n[16] \$I302 DP8TPrecharge_bl2
X$23 \$100 bl[20] bl_n[20] \$98 bl_n[21] bl[21] bl[22] bl_n[22] bl_n[23] bl[23]
+ mux[0] vss mux[1] mux[2] mux[3] DP8TColMux_4C_bl2
X$24 precharge_n vdd bl[17] bl_n[17] \$I302 DP8TPrecharge_bl2
X$25 precharge_n vdd bl[18] bl_n[18] \$I302 DP8TPrecharge_bl2
X$26 precharge_n vdd bl[19] bl_n[19] \$I302 DP8TPrecharge_bl2
X$27 precharge_n vdd bl[20] bl_n[20] \$I302 DP8TPrecharge_bl2
X$28 \$95 bl[24] bl_n[24] \$96 bl_n[25] bl[25] bl[26] bl_n[26] bl_n[27] bl[27]
+ mux[0] vss mux[1] mux[2] mux[3] DP8TColMux_4C_bl2
X$29 precharge_n vdd bl[21] bl_n[21] \$I302 DP8TPrecharge_bl2
X$30 precharge_n vdd bl[22] bl_n[22] \$I302 DP8TPrecharge_bl2
X$31 precharge_n vdd bl[23] bl_n[23] \$I302 DP8TPrecharge_bl2
X$32 precharge_n vdd bl[24] bl_n[24] \$I302 DP8TPrecharge_bl2
X$33 \$94 bl[28] bl_n[28] \$92 bl_n[29] bl[29] bl[30] bl_n[30] bl_n[31] bl[31]
+ mux[0] vss mux[1] mux[2] mux[3] DP8TColMux_4C_bl2
X$34 precharge_n vdd bl[25] bl_n[25] \$I302 DP8TPrecharge_bl2
X$35 precharge_n vdd bl[26] bl_n[26] \$I302 DP8TPrecharge_bl2
X$36 precharge_n vdd bl[27] bl_n[27] \$I302 DP8TPrecharge_bl2
X$37 precharge_n vdd bl[28] bl_n[28] \$I302 DP8TPrecharge_bl2
X$38 precharge_n vdd bl[29] bl_n[29] \$I302 DP8TPrecharge_bl2
X$39 precharge_n vdd bl[30] bl_n[30] \$I302 DP8TPrecharge_bl2
X$40 precharge_n vdd bl[31] bl_n[31] \$I302 DP8TPrecharge_bl2
X$41 \$93 vss \$97 vdd q[0] d[0] \$12 \$16 DP8TReadWrite_4M
X$42 \$101 vss \$99 vdd q[1] d[1] \$12 \$16 DP8TReadWrite_4M
X$43 \$106 vss \$107 vdd q[2] d[2] \$12 \$16 DP8TReadWrite_4M
X$44 \$104 vss \$105 vdd q[3] d[3] \$12 \$16 DP8TReadWrite_4M
X$45 \$102 vss \$103 vdd q[4] d[4] \$12 \$16 DP8TReadWrite_4M
X$46 \$100 vss \$98 vdd q[5] d[5] \$12 \$16 DP8TReadWrite_4M
X$47 \$95 vss \$96 vdd q[6] d[6] \$12 \$16 DP8TReadWrite_4M
X$48 vss clk we we_en \$16 vdd \$12 DP8TClockWE
X$49 \$94 vss \$92 vdd q[7] d[7] \$12 \$16 DP8TReadWrite_4M
.ENDS DP8TColumnPeriphery_8B4M_bl2

.SUBCKT DP8TArray_128X32BC vss wl2[13] wl1[13] wl2[14] wl1[15] wl1[14] wl1[16]
+ wl2[21] wl2[15] wl2[16] vdd wl2[32] wl2[28] wl1[28] wl1[29] wl2[29] wl2[30]
+ wl1[30] wl1[31] wl2[31] wl2[27] wl1[32] wl1[33] wl2[33] wl2[34] wl1[34]
+ wl1[35] wl2[35] wl2[36] wl1[36] wl1[37] wl1[22] wl2[17] wl2[18] wl1[18]
+ wl1[19] wl2[19] wl2[20] wl1[20] wl1[21] wl1[9] wl2[22] wl1[17] wl1[23]
+ wl2[23] wl2[24] wl1[24] wl1[25] wl2[25] wl2[26] wl1[26] wl1[27] wl2[12]
+ wl1[12] wl2[0] wl1[0] wl1[1] wl2[1] wl2[2] wl1[2] wl1[3] wl2[3] wl2[4] wl1[4]
+ wl1[5] wl2[6] wl2[11] wl1[11] wl1[10] wl2[10] wl2[9] wl1[8] wl2[8] wl2[7]
+ wl1[7] wl1[6] wl2[5] bl1[0] bl2[0] bl1_n[0] bl2_n[0] bl2_n[1] bl1_n[1] bl2[1]
+ bl1[1] bl1[2] bl2[2] bl1_n[2] bl2_n[2] bl2_n[3] bl1_n[3] bl2[3] bl1[3] bl1[4]
+ bl2[4] bl1_n[4] bl2_n[4] bl2_n[5] bl1_n[5] bl2[5] bl1[5] bl1[6] bl2[6]
+ bl1_n[6] bl2_n[6] bl2_n[7] bl1_n[7] bl2[7] bl1[7] bl1[8] bl2[8] bl1_n[8]
+ bl2_n[8] bl2_n[9] bl1_n[9] bl2[9] bl1[9] bl1[10] bl2[10] bl1_n[10] bl2_n[10]
+ bl2_n[11] bl1_n[11] bl2[11] bl1[11] bl1[12] bl2[12] bl1_n[12] bl2_n[12]
+ bl2_n[13] bl1_n[13] bl2[13] bl1[13] bl1[14] bl2[14] bl1_n[14] bl2_n[14]
+ bl2_n[15] bl1_n[15] bl2[15] bl1[15] wl1[46] wl2[38] wl2[53] wl2[37] wl2[54]
+ wl1[53] wl1[54] wl1[55] wl2[55] wl2[56] wl1[56] wl1[57] wl2[57] wl2[58]
+ wl1[58] wl1[59] wl2[59] wl2[60] wl1[60] wl1[61] wl2[61] wl2[62] wl1[62]
+ wl1[63] wl2[63] wl2[46] wl2[43] wl2[49] wl2[42] wl1[49] wl1[42] wl1[48]
+ wl1[43] wl2[45] wl2[48] wl1[52] wl1[38] wl2[44] wl1[44] wl1[47] wl2[47]
+ wl1[45] wl1[41] wl2[51] wl2[40] wl1[51] wl1[40] wl2[39] wl1[50] wl2[52]
+ wl1[39] wl2[50] wl2[41] bl1[16] bl2[16] bl1_n[16] bl2_n[16] bl2_n[17]
+ bl1_n[17] bl2[17] bl1[17] bl1[18] bl2[18] bl1_n[18] bl2_n[18] bl2_n[19]
+ bl1_n[19] bl2[19] bl1[19] bl1[20] bl2[20] bl1_n[20] bl2_n[20] bl2_n[21]
+ bl1_n[21] bl2[21] bl1[21] bl1[22] bl2[22] bl1_n[22] bl2_n[22] bl2_n[23]
+ bl1_n[23] bl2[23] bl1[23] bl1[24] bl2[24] bl1_n[24] bl2_n[24] bl2_n[25]
+ bl1_n[25] bl2[25] bl1[25] bl1[26] bl2[26] bl1_n[26] bl2_n[26] bl2_n[27]
+ bl1_n[27] bl2[27] bl1[27] bl1[28] bl2[28] bl1_n[28] bl2_n[28] bl2_n[29]
+ bl1_n[29] bl2[29] bl1[29] bl1[30] bl2[30] bl1_n[30] bl2_n[30] bl2_n[31]
+ bl1_n[31] bl2[31] bl1[31] wl2[115] wl2[120] wl1[87] wl2[119] wl1[119]
+ wl1[118] wl2[87] wl2[118] wl2[117] wl1[117] wl2[88] wl1[116] wl2[116]
+ wl1[120] wl1[88] wl1[115] wl1[114] wl1[89] wl2[114] wl2[113] wl1[113] wl2[89]
+ wl1[112] wl1[124] wl2[84] wl2[127] wl1[84] wl1[127] wl1[126] wl2[126] wl1[85]
+ wl2[125] wl1[125] wl2[112] wl2[85] wl2[124] wl2[123] wl1[123] wl2[86]
+ wl1[122] wl2[122] wl2[121] wl1[86] wl1[121] wl2[99] wl2[103] wl1[93] wl1[103]
+ wl1[102] wl2[102] wl2[93] wl2[101] wl1[101] wl1[100] wl2[94] wl2[100]
+ wl2[104] wl1[99] wl1[94] wl1[98] wl2[98] wl1[95] wl2[97] wl2[95] wl1[97]
+ wl1[96] wl1[108] wl2[90] wl2[111] wl1[111] wl1[90] wl1[110] wl2[110] wl2[109]
+ wl1[91] wl1[109] wl2[96] wl2[108] wl2[91] wl2[107] wl1[107] wl1[106] wl2[92]
+ wl2[106] wl2[105] wl1[105] wl1[92] wl1[104] wl1[68] wl2[73] wl1[73] wl1[72]
+ wl2[72] wl2[71] wl1[71] wl1[70] wl2[70] wl2[69] wl1[69] wl1[65] wl2[68]
+ wl2[67] wl1[67] wl1[66] wl2[66] wl2[65] wl1[64] wl2[64] wl2[83] wl1[74]
+ wl1[83] wl1[82] wl2[82] wl2[81] wl1[81] wl1[80] wl2[80] wl2[79] wl1[78]
+ wl2[74] wl1[75] wl2[75] wl2[76] wl1[79] wl1[76] wl2[78] wl1[77] wl2[77]
X$2 vss wl1[6] wl1[7] wl1[21] wl1[20] wl2[21] wl2[6] wl2[22] wl1[4] wl2[5]
+ wl1[22] wl1[5] wl2[19] wl2[4] wl2[3] wl1[3] wl1[23] wl2[8] wl1[11] wl2[12]
+ wl1[10] wl1[12] wl2[10] wl1[13] wl2[9] wl2[13] wl1[9] wl2[14] wl1[8] wl1[14]
+ wl1[15] wl2[20] wl2[15] wl2[7] vdd wl2[16] wl1[16] wl1[17] wl2[17] wl2[18]
+ wl1[18] wl1[19] wl2[11] wl2[2] wl2[1] wl1[1] wl1[0] wl2[0] wl1[2] bl1[0]
+ bl2[0] bl1_n[0] bl2_n[0] bl2_n[1] bl1_n[1] bl2[1] bl1[1] bl1[2] bl2[2]
+ bl1_n[2] bl2_n[2] bl2_n[3] bl1_n[3] bl2[3] bl1[3] bl1[4] bl2[4] bl1_n[4]
+ bl2_n[4] bl2_n[5] bl1_n[5] bl2[5] bl1[5] bl1[6] bl2[6] bl1_n[6] bl2_n[6]
+ bl2_n[7] bl1_n[7] bl2[7] bl1[7] bl1[8] bl2[8] bl1_n[8] bl2_n[8] bl2_n[9]
+ bl1_n[9] bl2[9] bl1[9] bl1[10] bl2[10] bl1_n[10] bl2_n[10] bl2_n[11]
+ bl1_n[11] bl2[11] bl1[11] bl1[12] bl2[12] bl1_n[12] bl2_n[12] bl2_n[13]
+ bl1_n[13] bl2[13] bl1[13] bl1[14] bl2[14] bl1_n[14] bl2_n[14] bl2_n[15]
+ bl1_n[15] bl2[15] bl1[15] wl2[31] wl1[31] wl1[30] wl2[30] wl2[29] wl1[29]
+ wl1[28] wl2[28] wl2[26] wl2[27] wl1[27] wl1[26] wl2[23] wl2[24] wl1[24]
+ wl1[25] wl2[25] bl1[16] bl2[16] bl1_n[16] bl2_n[16] bl2_n[17] bl1_n[17]
+ bl2[17] bl1[17] bl1[18] bl2[18] bl1_n[18] bl2_n[18] bl2_n[19] bl1_n[19]
+ bl2[19] bl1[19] bl1[20] bl2[20] bl1_n[20] bl2_n[20] bl2_n[21] bl1_n[21]
+ bl2[21] bl1[21] bl1[22] bl2[22] bl1_n[22] bl2_n[22] bl2_n[23] bl1_n[23]
+ bl2[23] bl1[23] bl1[24] bl2[24] bl1_n[24] bl2_n[24] bl2_n[25] bl1_n[25]
+ bl2[25] bl1[25] bl1[26] bl2[26] bl1_n[26] bl2_n[26] bl2_n[27] bl1_n[27]
+ bl2[27] bl1[27] bl1[28] bl2[28] bl1_n[28] bl2_n[28] bl2_n[29] bl1_n[29]
+ bl2[29] bl1[29] bl1[30] bl2[30] bl1_n[30] bl2_n[30] bl2_n[31] bl1_n[31]
+ bl2[31] bl1[31] wl2[38] wl1[38] wl1[32] wl1[33] wl2[63] wl2[37] wl1[37]
+ wl1[36] wl2[32] wl2[36] wl2[35] wl1[35] wl1[34] wl2[34] wl2[33] wl1[57]
+ wl1[51] wl2[51] wl2[52] wl1[52] wl1[53] wl2[53] wl2[54] wl1[54] wl1[55]
+ wl2[55] wl2[56] wl1[56] wl1[50] wl2[57] wl2[58] wl1[58] wl1[59] wl2[59]
+ wl2[60] wl1[60] wl1[61] wl2[61] wl2[62] wl1[62] wl1[63] wl2[45] wl2[39]
+ wl2[40] wl1[40] wl1[41] wl2[41] wl2[42] wl1[42] wl1[43] wl2[43] wl2[44]
+ wl1[44] wl1[45] wl1[39] wl2[46] wl1[46] wl1[47] wl2[47] wl2[48] wl1[48]
+ wl1[49] wl2[49] wl2[50] DP8TArray_64X32
X$4 vss wl1[70] wl1[71] wl1[85] wl1[84] wl2[85] wl2[70] wl2[86] wl1[68] wl2[69]
+ wl1[86] wl1[69] wl2[83] wl2[68] wl2[67] wl1[67] wl1[87] wl2[72] wl1[75]
+ wl2[76] wl1[74] wl1[76] wl2[74] wl1[77] wl2[73] wl2[77] wl1[73] wl2[78]
+ wl1[72] wl1[78] wl1[79] wl2[84] wl2[79] wl2[71] vdd wl2[80] wl1[80] wl1[81]
+ wl2[81] wl2[82] wl1[82] wl1[83] wl2[75] wl2[66] wl2[65] wl1[65] wl1[64]
+ wl2[64] wl1[66] bl1[0] bl2[0] bl1_n[0] bl2_n[0] bl2_n[1] bl1_n[1] bl2[1]
+ bl1[1] bl1[2] bl2[2] bl1_n[2] bl2_n[2] bl2_n[3] bl1_n[3] bl2[3] bl1[3] bl1[4]
+ bl2[4] bl1_n[4] bl2_n[4] bl2_n[5] bl1_n[5] bl2[5] bl1[5] bl1[6] bl2[6]
+ bl1_n[6] bl2_n[6] bl2_n[7] bl1_n[7] bl2[7] bl1[7] bl1[8] bl2[8] bl1_n[8]
+ bl2_n[8] bl2_n[9] bl1_n[9] bl2[9] bl1[9] bl1[10] bl2[10] bl1_n[10] bl2_n[10]
+ bl2_n[11] bl1_n[11] bl2[11] bl1[11] bl1[12] bl2[12] bl1_n[12] bl2_n[12]
+ bl2_n[13] bl1_n[13] bl2[13] bl1[13] bl1[14] bl2[14] bl1_n[14] bl2_n[14]
+ bl2_n[15] bl1_n[15] bl2[15] bl1[15] wl2[95] wl1[95] wl1[94] wl2[94] wl2[93]
+ wl1[93] wl1[92] wl2[92] wl2[90] wl2[91] wl1[91] wl1[90] wl2[87] wl2[88]
+ wl1[88] wl1[89] wl2[89] bl1[16] bl2[16] bl1_n[16] bl2_n[16] bl2_n[17]
+ bl1_n[17] bl2[17] bl1[17] bl1[18] bl2[18] bl1_n[18] bl2_n[18] bl2_n[19]
+ bl1_n[19] bl2[19] bl1[19] bl1[20] bl2[20] bl1_n[20] bl2_n[20] bl2_n[21]
+ bl1_n[21] bl2[21] bl1[21] bl1[22] bl2[22] bl1_n[22] bl2_n[22] bl2_n[23]
+ bl1_n[23] bl2[23] bl1[23] bl1[24] bl2[24] bl1_n[24] bl2_n[24] bl2_n[25]
+ bl1_n[25] bl2[25] bl1[25] bl1[26] bl2[26] bl1_n[26] bl2_n[26] bl2_n[27]
+ bl1_n[27] bl2[27] bl1[27] bl1[28] bl2[28] bl1_n[28] bl2_n[28] bl2_n[29]
+ bl1_n[29] bl2[29] bl1[29] bl1[30] bl2[30] bl1_n[30] bl2_n[30] bl2_n[31]
+ bl1_n[31] bl2[31] bl1[31] wl2[102] wl1[102] wl1[96] wl1[97] wl2[127] wl2[101]
+ wl1[101] wl1[100] wl2[96] wl2[100] wl2[99] wl1[99] wl1[98] wl2[98] wl2[97]
+ wl1[121] wl1[115] wl2[115] wl2[116] wl1[116] wl1[117] wl2[117] wl2[118]
+ wl1[118] wl1[119] wl2[119] wl2[120] wl1[120] wl1[114] wl2[121] wl2[122]
+ wl1[122] wl1[123] wl2[123] wl2[124] wl1[124] wl1[125] wl2[125] wl2[126]
+ wl1[126] wl1[127] wl2[109] wl2[103] wl2[104] wl1[104] wl1[105] wl2[105]
+ wl2[106] wl1[106] wl1[107] wl2[107] wl2[108] wl1[108] wl1[109] wl1[103]
+ wl2[110] wl1[110] wl1[111] wl2[111] wl2[112] wl1[112] wl1[113] wl2[113]
+ wl2[114] DP8TArray_64X32
.ENDS DP8TArray_128X32BC

.SUBCKT DP8TColumnPeriphery_8B4M_bl1 vss we d[0] d[1] vdd d[2] d[3] d[4] d[5]
+ d[6] d[7] clk we_en q[0] q[1] q[2] q[3] q[4] q[5] q[6] q[7] bl[0] bl_n[0]
+ bl_n[1] bl[1] bl[2] bl_n[2] bl_n[3] bl[3] bl[4] bl_n[4] bl_n[5] bl[5] bl[6]
+ bl_n[6] bl_n[7] bl[7] bl[8] bl_n[8] bl_n[9] bl[9] bl[10] bl_n[10] bl_n[11]
+ bl[11] bl[12] bl_n[12] bl_n[13] bl[13] bl[14] bl_n[14] bl_n[15] bl[15] mux[0]
+ bl[16] bl_n[16] bl_n[17] bl[17] bl[18] bl_n[18] bl_n[19] bl[19] bl[20]
+ bl_n[20] bl_n[21] bl[21] bl[22] bl_n[22] bl_n[23] bl[23] bl[24] bl_n[24]
+ bl_n[25] bl[25] bl[26] bl_n[26] bl_n[27] bl[27] bl[28] bl_n[28] bl_n[29]
+ bl[29] bl[30] bl_n[30] bl_n[31] bl[31] mux[2] mux[1] precharge_n mux[3] \$I358
X$1 \$101 bl[4] bl_n[4] \$99 bl_n[5] bl[5] bl[6] bl_n[6] bl_n[7] bl[7] mux[0]
+ vss mux[1] mux[2] mux[3] DP8TColMux_4C_bl1
X$2 \$93 bl[0] bl_n[0] \$97 bl_n[1] bl[1] bl[2] bl_n[2] bl_n[3] bl[3] mux[0]
+ vss mux[1] mux[2] mux[3] DP8TColMux_4C_bl1
X$3 precharge_n vdd bl[0] bl_n[0] \$I358 DP8TPrecharge_bl1
X$4 precharge_n vdd bl[1] bl_n[1] \$I358 DP8TPrecharge_bl1
X$5 precharge_n vdd bl[2] bl_n[2] \$I358 DP8TPrecharge_bl1
X$6 precharge_n vdd bl[3] bl_n[3] \$I358 DP8TPrecharge_bl1
X$7 precharge_n vdd bl[4] bl_n[4] \$I358 DP8TPrecharge_bl1
X$8 \$106 bl[8] bl_n[8] \$107 bl_n[9] bl[9] bl[10] bl_n[10] bl_n[11] bl[11]
+ mux[0] vss mux[1] mux[2] mux[3] DP8TColMux_4C_bl1
X$9 precharge_n vdd bl[5] bl_n[5] \$I358 DP8TPrecharge_bl1
X$10 precharge_n vdd bl[6] bl_n[6] \$I358 DP8TPrecharge_bl1
X$11 precharge_n vdd bl[7] bl_n[7] \$I358 DP8TPrecharge_bl1
X$12 precharge_n vdd bl[8] bl_n[8] \$I358 DP8TPrecharge_bl1
X$13 \$104 bl[12] bl_n[12] \$105 bl_n[13] bl[13] bl[14] bl_n[14] bl_n[15]
+ bl[15] mux[0] vss mux[1] mux[2] mux[3] DP8TColMux_4C_bl1
X$14 precharge_n vdd bl[9] bl_n[9] \$I358 DP8TPrecharge_bl1
X$15 precharge_n vdd bl[10] bl_n[10] \$I358 DP8TPrecharge_bl1
X$16 precharge_n vdd bl[11] bl_n[11] \$I358 DP8TPrecharge_bl1
X$17 precharge_n vdd bl[12] bl_n[12] \$I358 DP8TPrecharge_bl1
X$18 \$102 bl[16] bl_n[16] \$103 bl_n[17] bl[17] bl[18] bl_n[18] bl_n[19]
+ bl[19] mux[0] vss mux[1] mux[2] mux[3] DP8TColMux_4C_bl1
X$19 precharge_n vdd bl[13] bl_n[13] \$I358 DP8TPrecharge_bl1
X$20 precharge_n vdd bl[14] bl_n[14] \$I358 DP8TPrecharge_bl1
X$21 precharge_n vdd bl[15] bl_n[15] \$I358 DP8TPrecharge_bl1
X$22 precharge_n vdd bl[16] bl_n[16] \$I358 DP8TPrecharge_bl1
X$23 \$100 bl[20] bl_n[20] \$98 bl_n[21] bl[21] bl[22] bl_n[22] bl_n[23] bl[23]
+ mux[0] vss mux[1] mux[2] mux[3] DP8TColMux_4C_bl1
X$24 precharge_n vdd bl[17] bl_n[17] \$I358 DP8TPrecharge_bl1
X$25 precharge_n vdd bl[18] bl_n[18] \$I358 DP8TPrecharge_bl1
X$26 precharge_n vdd bl[19] bl_n[19] \$I358 DP8TPrecharge_bl1
X$27 precharge_n vdd bl[20] bl_n[20] \$I358 DP8TPrecharge_bl1
X$28 \$95 bl[24] bl_n[24] \$96 bl_n[25] bl[25] bl[26] bl_n[26] bl_n[27] bl[27]
+ mux[0] vss mux[1] mux[2] mux[3] DP8TColMux_4C_bl1
X$29 precharge_n vdd bl[21] bl_n[21] \$I358 DP8TPrecharge_bl1
X$30 precharge_n vdd bl[22] bl_n[22] \$I358 DP8TPrecharge_bl1
X$31 precharge_n vdd bl[23] bl_n[23] \$I358 DP8TPrecharge_bl1
X$32 precharge_n vdd bl[24] bl_n[24] \$I358 DP8TPrecharge_bl1
X$33 \$94 bl[28] bl_n[28] \$92 bl_n[29] bl[29] bl[30] bl_n[30] bl_n[31] bl[31]
+ mux[0] vss mux[1] mux[2] mux[3] DP8TColMux_4C_bl1
X$34 precharge_n vdd bl[25] bl_n[25] \$I358 DP8TPrecharge_bl1
X$35 precharge_n vdd bl[26] bl_n[26] \$I358 DP8TPrecharge_bl1
X$36 precharge_n vdd bl[27] bl_n[27] \$I358 DP8TPrecharge_bl1
X$37 precharge_n vdd bl[28] bl_n[28] \$I358 DP8TPrecharge_bl1
X$38 precharge_n vdd bl[29] bl_n[29] \$I358 DP8TPrecharge_bl1
X$39 precharge_n vdd bl[30] bl_n[30] \$I358 DP8TPrecharge_bl1
X$40 precharge_n vdd bl[31] bl_n[31] \$I358 DP8TPrecharge_bl1
X$41 \$93 vss \$97 vdd q[0] d[0] \$12 \$16 DP8TReadWrite_4M
X$42 \$101 vss \$99 vdd q[1] d[1] \$12 \$16 DP8TReadWrite_4M
X$43 \$106 vss \$107 vdd q[2] d[2] \$12 \$16 DP8TReadWrite_4M
X$44 \$104 vss \$105 vdd q[3] d[3] \$12 \$16 DP8TReadWrite_4M
X$45 \$102 vss \$103 vdd q[4] d[4] \$12 \$16 DP8TReadWrite_4M
X$46 \$100 vss \$98 vdd q[5] d[5] \$12 \$16 DP8TReadWrite_4M
X$47 \$95 vss \$96 vdd q[6] d[6] \$12 \$16 DP8TReadWrite_4M
X$48 vss clk we we_en \$16 vdd \$12 DP8TClockWE
X$49 \$94 vss \$92 vdd q[7] d[7] \$12 \$16 DP8TReadWrite_4M
.ENDS DP8TColumnPeriphery_8B4M_bl1

.SUBCKT DP8TNonOverlapClock_8S1R vss vdd firststage[7] secondstage[7] clk
X$1 vss vdd secondstage[8] secondstage[7] inv_x0
X$2 vss vdd secondstage[7] secondstage[6] inv_x0
X$3 vss vdd secondstage[6] secondstage[5] inv_x0
X$4 vss vdd secondstage[5] secondstage[4] inv_x0
X$5 vss vdd secondstage[4] secondstage[3] inv_x0
X$6 vss vdd secondstage[3] secondstage[2] inv_x0
X$7 vss vdd secondstage[2] secondstage[1] inv_x0
X$8 vss vdd secondstage[1] secondstage[0] inv_x0
X$9 vss vdd \$23 secondstage[0] firststage[8] nand2_x0
X$10 vss vdd \$23 clk inv_x0
X$11 vss vdd clk firststage[0] secondstage[8] nand2_x0
X$12 vss vdd firststage[1] firststage[0] inv_x0
X$13 vss vdd firststage[2] firststage[1] inv_x0
X$14 vss vdd firststage[3] firststage[2] inv_x0
X$15 vss vdd firststage[4] firststage[3] inv_x0
X$16 vss vdd firststage[5] firststage[4] inv_x0
X$17 vss vdd firststage[6] firststage[5] inv_x0
X$18 vss vdd firststage[7] firststage[6] inv_x0
X$19 vss vdd firststage[8] firststage[7] inv_x0
.ENDS DP8TNonOverlapClock_8S1R

.SUBCKT inv_x1 vss vdd nq i
M$1 vss i nq vss sg13_lv_nmos L=0.13u W=1.46u AS=0.4964p AD=0.4964p PS=3.6u
+ PD=3.6u
M$2 vdd i nq vdd sg13_lv_pmos L=0.13u W=1.45u AS=0.493p AD=0.493p PS=3.58u
+ PD=3.58u
.ENDS inv_x1

.SUBCKT buf_x1 vdd vss i q
M$1 \$1 i vss vss sg13_lv_nmos L=0.13u W=0.78u AS=0.2652p AD=0.2092p PS=2.24u
+ PD=1.48u
M$2 vss \$1 q vss sg13_lv_nmos L=0.13u W=1.07u AS=0.2092p AD=0.3638p PS=1.48u
+ PD=2.82u
M$3 vdd i \$1 vdd sg13_lv_pmos L=0.13u W=0.78u AS=0.2075p AD=0.2652p PS=1.47u
+ PD=2.24u
M$4 vdd \$1 q vdd sg13_lv_pmos L=0.13u W=1.06u AS=0.2075p AD=0.3604p PS=1.47u
+ PD=2.8u
.ENDS buf_x1

.SUBCKT DP8TDec_inv_x2 vss vdd nq i
M$1 vss i nq vss sg13_lv_nmos L=0.13u W=5.6u AS=1.484p AD=1.484p PS=9.46u
+ PD=9.46u
M$3 vdd i nq vdd sg13_lv_pmos L=0.13u W=8.8u AS=2.332p AD=2.332p PS=14.26u
+ PD=14.26u
.ENDS DP8TDec_inv_x2

.SUBCKT DP8TDec_nand2_x0 vss vdd i0 nq i1
M$1 vss i0 \$6 vss sg13_lv_nmos L=0.13u W=0.78u AS=0.2652p AD=0.1482p PS=2.24u
+ PD=1.16u
M$2 \$6 i1 nq vss sg13_lv_nmos L=0.13u W=0.78u AS=0.1482p AD=0.312p PS=1.16u
+ PD=2.36u
M$3 vdd i0 nq vdd sg13_lv_pmos L=0.13u W=1.2u AS=0.408p AD=0.228p PS=3.08u
+ PD=1.58u
M$4 nq i1 vdd vdd sg13_lv_pmos L=0.13u W=1.2u AS=0.228p AD=0.48p PS=1.58u
+ PD=3.2u
.ENDS DP8TDec_nand2_x0

.SUBCKT DP8TRowDecoderDriverPage_2PD8R_wl1 vss wl[0] pd[0][1] pd[0][0] wl[1]
+ vdd wl[2] pd[0][3] pd[0][2] wl_en wl[3] wl[4] pd[0][5] pd[0][4] wl[5] wl[6]
+ pd[0][7] pd[0][6] page wl[7]
X$1 wl[1] vss \$10 vdd vss vdd DP8TWLDrive_26LN100WN26LP200WP_wl1
X$2 wl[0] vss \$3 vdd vss vdd DP8TWLDrive_26LN100WN26LP200WP_wl1
X$3 wl[2] vss \$12 vdd vss vdd DP8TWLDrive_26LN100WN26LP200WP_wl1
X$4 wl[3] vss \$18 vdd vss vdd DP8TWLDrive_26LN100WN26LP200WP_wl1
X$5 wl[4] vss \$19 vdd vss vdd DP8TWLDrive_26LN100WN26LP200WP_wl1
X$6 wl[5] vss \$23 vdd vss vdd DP8TWLDrive_26LN100WN26LP200WP_wl1
X$7 wl[6] vss \$24 vdd vss vdd DP8TWLDrive_26LN100WN26LP200WP_wl1
X$8 wl[7] vss \$31 vdd vss vdd DP8TWLDrive_26LN100WN26LP200WP_wl1
X$9 vss vdd \$3 wl_en pd[0][0] page \$10 pd[0][1] DP8TRowDecoderNand3X2
X$10 vss vdd \$12 wl_en pd[0][2] page \$18 pd[0][3] DP8TRowDecoderNand3X2
X$11 vss vdd \$19 wl_en pd[0][4] page \$23 pd[0][5] DP8TRowDecoderNand3X2
X$12 vss vdd \$24 wl_en pd[0][6] page \$31 pd[0][7] DP8TRowDecoderNand3X2
.ENDS DP8TRowDecoderDriverPage_2PD8R_wl1

.SUBCKT DP8TRowPredecoders_3_4B_wl1 vss vdd pd[0][0] page[0] pd[0][1] pd[0][2]
+ page[1] pd[0][3] pd[0][4] page[2] pd[0][5] page[3] pd[0][6] pd[0][7] page[4]
+ page[5] page[6] page[7] page[8] page[9] page[10] page[11] page[12] page[13]
+ page[14] page[15] clk a[0] a[1] a[2] a[3] a[4] a[5] a[6]
X$1 vss a[0] \$34 clk vdd DP8TDec_dff_x1
X$2 vss vdd \$27 \$34 DP8TDec_inv_x1
X$3 vdd vss \$27 \$28 \$29 pd[0][0] DP8TDec_and3_x1
X$4 vdd vss \$30 \$31 \$32 \$33 page[0] DP8TDec_and4_x1
X$5 vdd vss \$34 \$28 \$29 pd[0][1] DP8TDec_and3_x1
X$6 vss a[1] \$35 clk vdd DP8TDec_dff_x1
X$7 vdd vss \$27 \$35 \$29 pd[0][2] DP8TDec_and3_x1
X$8 vss vdd \$28 \$35 DP8TDec_inv_x1
X$9 vdd vss \$36 \$31 \$32 \$33 page[1] DP8TDec_and4_x1
X$10 vdd vss \$34 \$35 \$29 pd[0][3] DP8TDec_and3_x1
X$11 vss a[2] \$37 clk vdd DP8TDec_dff_x1
X$12 vdd vss \$27 \$28 \$37 pd[0][4] DP8TDec_and3_x1
X$13 vss vdd \$29 \$37 DP8TDec_inv_x1
X$14 vdd vss \$30 \$38 \$32 \$33 page[2] DP8TDec_and4_x1
X$15 vdd vss \$34 \$28 \$37 pd[0][5] DP8TDec_and3_x1
X$16 vss a[3] \$36 clk vdd DP8TDec_dff_x1
X$17 vdd vss \$36 \$38 \$32 \$33 page[3] DP8TDec_and4_x1
X$18 vss vdd \$30 \$36 DP8TDec_inv_x1
X$19 vdd vss \$27 \$35 \$37 pd[0][6] DP8TDec_and3_x1
X$20 vdd vss \$34 \$35 \$37 pd[0][7] DP8TDec_and3_x1
X$21 vss a[4] \$38 clk vdd DP8TDec_dff_x1
X$23 vss vdd \$31 \$38 DP8TDec_inv_x1
X$24 vdd vss \$30 \$31 \$39 \$33 page[4] DP8TDec_and4_x1
X$26 vss a[5] \$39 clk vdd DP8TDec_dff_x1
X$27 vdd vss \$36 \$31 \$39 \$33 page[5] DP8TDec_and4_x1
X$28 vss vdd \$32 \$39 DP8TDec_inv_x1
X$31 vss a[6] \$48 clk vdd DP8TDec_dff_x1
X$32 vdd vss \$30 \$38 \$39 \$33 page[6] DP8TDec_and4_x1
X$33 vss vdd \$33 \$48 DP8TDec_inv_x1
X$37 vdd vss \$36 \$38 \$39 \$33 page[7] DP8TDec_and4_x1
X$43 vdd vss \$30 \$31 \$32 \$48 page[8] DP8TDec_and4_x1
X$49 vdd vss \$36 \$31 \$32 \$48 page[9] DP8TDec_and4_x1
X$55 vdd vss \$30 \$38 \$32 \$48 page[10] DP8TDec_and4_x1
X$59 vdd vss \$36 \$38 \$32 \$48 page[11] DP8TDec_and4_x1
X$67 vdd vss \$30 \$31 \$39 \$48 page[12] DP8TDec_and4_x1
X$71 vdd vss \$36 \$31 \$39 \$48 page[13] DP8TDec_and4_x1
X$77 vdd vss \$30 \$38 \$39 \$48 page[14] DP8TDec_and4_x1
X$83 vdd vss \$36 \$38 \$39 \$48 page[15] DP8TDec_and4_x1
.ENDS DP8TRowPredecoders_3_4B_wl1

.SUBCKT DP8TWLDrive_26LN100WN26LP200WP_wl2 wl_drive vss wl_n vdd \$5 \$6
M$1 vss wl_n wl_drive \$5 sg13_lv_nmos L=0.13u W=1u AS=0.28p AD=0.28p PS=2.62u
+ PD=2.62u
M$3 vdd wl_n wl_drive \$6 sg13_lv_pmos L=0.13u W=2u AS=0.56p AD=0.56p PS=4.12u
+ PD=4.12u
.ENDS DP8TWLDrive_26LN100WN26LP200WP_wl2

.SUBCKT DP8TPrecharge_bl2 precharge_n vdd bl bl_n \$6
M$1 vdd precharge_n bl \$6 sg13_lv_pmos L=0.13u W=0.5u AS=0.3775p AD=0.3p
+ PS=2.51u PD=1.7u
M$2 bl precharge_n bl_n \$6 sg13_lv_pmos L=0.13u W=0.5u AS=0.3p AD=0.3p PS=1.7u
+ PD=1.7u
M$3 bl_n precharge_n vdd \$6 sg13_lv_pmos L=0.13u W=0.5u AS=0.3p AD=0.3775p
+ PS=1.7u PD=2.51u
.ENDS DP8TPrecharge_bl2

.SUBCKT DP8TColMux_4C_bl2 muxbl bl[0] bl_n[0] muxbl_n bl_n[1] bl[1] bl[2]
+ bl_n[2] bl_n[3] bl[3] mux[0] vss mux[1] mux[2] mux[3]
M$1 bl[1] mux[1] muxbl vss sg13_lv_nmos L=0.13u W=3.5u AS=1.19p AD=0.665p
+ PS=7.68u PD=3.88u
M$2 muxbl mux[2] bl[2] vss sg13_lv_nmos L=0.13u W=3.5u AS=0.665p AD=1.19p
+ PS=3.88u PD=7.68u
M$3 bl[3] mux[3] muxbl vss sg13_lv_nmos L=0.13u W=3.5u AS=1.19p AD=1.19p
+ PS=7.68u PD=7.68u
M$4 bl_n[0] mux[0] muxbl_n vss sg13_lv_nmos L=0.13u W=3.5u AS=1.19p AD=0.665p
+ PS=7.68u PD=3.88u
M$5 muxbl_n mux[1] bl_n[1] vss sg13_lv_nmos L=0.13u W=3.5u AS=0.665p AD=1.19p
+ PS=3.88u PD=7.68u
M$6 bl_n[2] mux[2] muxbl_n vss sg13_lv_nmos L=0.13u W=3.5u AS=1.19p AD=0.665p
+ PS=7.68u PD=3.88u
M$7 muxbl_n mux[3] bl_n[3] vss sg13_lv_nmos L=0.13u W=3.5u AS=0.665p AD=1.19p
+ PS=3.88u PD=7.68u
M$8 muxbl mux[0] bl[0] vss sg13_lv_nmos L=0.13u W=3.5u AS=1.19p AD=1.19p
+ PS=7.68u PD=7.68u
.ENDS DP8TColMux_4C_bl2

.SUBCKT DP8TArray_64X32 vss wl1[6] wl1[7] wl1[21] wl1[20] wl2[21] wl2[6]
+ wl2[22] wl1[4] wl2[5] wl1[22] wl1[5] wl2[19] wl2[4] wl2[3] wl1[3] wl1[23]
+ wl2[8] wl1[11] wl2[12] wl1[10] wl1[12] wl2[10] wl1[13] wl2[9] wl2[13] wl1[9]
+ wl2[14] wl1[8] wl1[14] wl1[15] wl2[20] wl2[15] wl2[7] vdd wl2[16] wl1[16]
+ wl1[17] wl2[17] wl2[18] wl1[18] wl1[19] wl2[11] wl2[2] wl2[1] wl1[1] wl1[0]
+ wl2[0] wl1[2] bl1[0] bl2[0] bl1_n[0] bl2_n[0] bl2_n[1] bl1_n[1] bl2[1] bl1[1]
+ bl1[2] bl2[2] bl1_n[2] bl2_n[2] bl2_n[3] bl1_n[3] bl2[3] bl1[3] bl1[4] bl2[4]
+ bl1_n[4] bl2_n[4] bl2_n[5] bl1_n[5] bl2[5] bl1[5] bl1[6] bl2[6] bl1_n[6]
+ bl2_n[6] bl2_n[7] bl1_n[7] bl2[7] bl1[7] bl1[8] bl2[8] bl1_n[8] bl2_n[8]
+ bl2_n[9] bl1_n[9] bl2[9] bl1[9] bl1[10] bl2[10] bl1_n[10] bl2_n[10] bl2_n[11]
+ bl1_n[11] bl2[11] bl1[11] bl1[12] bl2[12] bl1_n[12] bl2_n[12] bl2_n[13]
+ bl1_n[13] bl2[13] bl1[13] bl1[14] bl2[14] bl1_n[14] bl2_n[14] bl2_n[15]
+ bl1_n[15] bl2[15] bl1[15] wl2[31] wl1[31] wl1[30] wl2[30] wl2[29] wl1[29]
+ wl1[28] wl2[28] wl2[26] wl2[27] wl1[27] wl1[26] wl2[23] wl2[24] wl1[24]
+ wl1[25] wl2[25] bl1[16] bl2[16] bl1_n[16] bl2_n[16] bl2_n[17] bl1_n[17]
+ bl2[17] bl1[17] bl1[18] bl2[18] bl1_n[18] bl2_n[18] bl2_n[19] bl1_n[19]
+ bl2[19] bl1[19] bl1[20] bl2[20] bl1_n[20] bl2_n[20] bl2_n[21] bl1_n[21]
+ bl2[21] bl1[21] bl1[22] bl2[22] bl1_n[22] bl2_n[22] bl2_n[23] bl1_n[23]
+ bl2[23] bl1[23] bl1[24] bl2[24] bl1_n[24] bl2_n[24] bl2_n[25] bl1_n[25]
+ bl2[25] bl1[25] bl1[26] bl2[26] bl1_n[26] bl2_n[26] bl2_n[27] bl1_n[27]
+ bl2[27] bl1[27] bl1[28] bl2[28] bl1_n[28] bl2_n[28] bl2_n[29] bl1_n[29]
+ bl2[29] bl1[29] bl1[30] bl2[30] bl1_n[30] bl2_n[30] bl2_n[31] bl1_n[31]
+ bl2[31] bl1[31] wl2[38] wl1[38] wl1[32] wl1[33] wl2[63] wl2[37] wl1[37]
+ wl1[36] wl2[32] wl2[36] wl2[35] wl1[35] wl1[34] wl2[34] wl2[33] wl1[57]
+ wl1[51] wl2[51] wl2[52] wl1[52] wl1[53] wl2[53] wl2[54] wl1[54] wl1[55]
+ wl2[55] wl2[56] wl1[56] wl1[50] wl2[57] wl2[58] wl1[58] wl1[59] wl2[59]
+ wl2[60] wl1[60] wl1[61] wl2[61] wl2[62] wl1[62] wl1[63] wl2[45] wl2[39]
+ wl2[40] wl1[40] wl1[41] wl2[41] wl2[42] wl1[42] wl1[43] wl2[43] wl2[44]
+ wl1[44] wl1[45] wl1[39] wl2[46] wl1[46] wl1[47] wl2[47] wl2[48] wl1[48]
+ wl1[49] wl2[49] wl2[50]
X$2 vss bl1[0] bl2[0] bl1_n[0] bl2_n[0] bl2_n[1] bl1_n[1] bl2[1] bl1[1] bl1[2]
+ bl2[2] bl1_n[2] bl2_n[2] bl2_n[3] bl1_n[3] bl2[3] bl1[3] bl1[4] bl2[4]
+ bl1_n[4] bl2_n[4] bl2_n[5] bl1_n[5] bl2[5] bl1[5] bl1[6] bl2[6] bl1_n[6]
+ bl2_n[6] bl2_n[7] bl1_n[7] bl2[7] bl1[7] bl1[8] bl2[8] bl1_n[8] bl2_n[8]
+ bl2_n[9] bl1_n[9] bl2[9] bl1[9] bl1[10] bl2[10] bl1_n[10] bl2_n[10] bl2_n[11]
+ bl1_n[11] bl2[11] bl1[11] bl1[12] bl2[12] bl1_n[12] bl2_n[12] bl2_n[13]
+ bl1_n[13] bl2[13] bl1[13] bl1[14] bl2[14] bl1_n[14] bl2_n[14] bl2_n[15]
+ bl1_n[15] bl2[15] bl1[15] wl1[10] wl2[5] wl2[10] wl2[9] wl1[9] wl1[8] wl1[11]
+ wl2[11] wl2[12] wl1[12] wl1[13] wl2[13] wl2[14] wl1[14] wl1[15] wl2[15]
+ wl2[8] wl1[2] wl2[2] wl1[3] wl2[1] wl2[3] wl1[1] wl2[4] wl1[0] wl1[4] wl2[0]
+ wl1[5] wl2[6] wl1[6] wl1[7] wl2[7] bl1[16] bl2[16] bl1_n[16] bl2_n[16]
+ bl2_n[17] bl1_n[17] bl2[17] bl1[17] bl1[18] bl2[18] bl1_n[18] bl2_n[18]
+ bl2_n[19] bl1_n[19] bl2[19] bl1[19] bl1[20] bl2[20] bl1_n[20] bl2_n[20]
+ bl2_n[21] bl1_n[21] bl2[21] bl1[21] bl1[22] bl2[22] bl1_n[22] bl2_n[22]
+ bl2_n[23] bl1_n[23] bl2[23] bl1[23] bl1[24] bl2[24] bl1_n[24] bl2_n[24]
+ bl2_n[25] bl1_n[25] bl2[25] bl1[25] bl1[26] bl2[26] bl1_n[26] bl2_n[26]
+ bl2_n[27] bl1_n[27] bl2[27] bl1[27] bl1[28] bl2[28] bl1_n[28] bl2_n[28]
+ bl2_n[29] bl1_n[29] bl2[29] bl1[29] bl1[30] bl2[30] bl1_n[30] bl2_n[30]
+ bl2_n[31] bl1_n[31] bl2[31] bl1[31] wl1[29] wl2[29] wl1[28] wl2[30] wl1[30]
+ wl2[28] wl1[31] wl2[31] wl2[27] wl1[24] wl2[18] wl2[23] wl1[23] wl1[22]
+ wl2[22] wl2[21] wl1[21] wl1[20] wl2[20] wl2[19] wl1[19] wl1[18] wl1[27]
+ wl2[17] wl1[17] wl1[16] wl2[24] wl2[16] vdd wl1[25] wl2[25] wl2[26] wl1[26]
+ DP8TArray_32X32
X$3 vss bl1[0] bl2[0] bl1_n[0] bl2_n[0] bl2_n[1] bl1_n[1] bl2[1] bl1[1] bl1[2]
+ bl2[2] bl1_n[2] bl2_n[2] bl2_n[3] bl1_n[3] bl2[3] bl1[3] bl1[4] bl2[4]
+ bl1_n[4] bl2_n[4] bl2_n[5] bl1_n[5] bl2[5] bl1[5] bl1[6] bl2[6] bl1_n[6]
+ bl2_n[6] bl2_n[7] bl1_n[7] bl2[7] bl1[7] bl1[8] bl2[8] bl1_n[8] bl2_n[8]
+ bl2_n[9] bl1_n[9] bl2[9] bl1[9] bl1[10] bl2[10] bl1_n[10] bl2_n[10] bl2_n[11]
+ bl1_n[11] bl2[11] bl1[11] bl1[12] bl2[12] bl1_n[12] bl2_n[12] bl2_n[13]
+ bl1_n[13] bl2[13] bl1[13] bl1[14] bl2[14] bl1_n[14] bl2_n[14] bl2_n[15]
+ bl1_n[15] bl2[15] bl1[15] wl1[42] wl2[37] wl2[42] wl2[41] wl1[41] wl1[40]
+ wl1[43] wl2[43] wl2[44] wl1[44] wl1[45] wl2[45] wl2[46] wl1[46] wl1[47]
+ wl2[47] wl2[40] wl1[34] wl2[34] wl1[35] wl2[33] wl2[35] wl1[33] wl2[36]
+ wl1[32] wl1[36] wl2[32] wl1[37] wl2[38] wl1[38] wl1[39] wl2[39] bl1[16]
+ bl2[16] bl1_n[16] bl2_n[16] bl2_n[17] bl1_n[17] bl2[17] bl1[17] bl1[18]
+ bl2[18] bl1_n[18] bl2_n[18] bl2_n[19] bl1_n[19] bl2[19] bl1[19] bl1[20]
+ bl2[20] bl1_n[20] bl2_n[20] bl2_n[21] bl1_n[21] bl2[21] bl1[21] bl1[22]
+ bl2[22] bl1_n[22] bl2_n[22] bl2_n[23] bl1_n[23] bl2[23] bl1[23] bl1[24]
+ bl2[24] bl1_n[24] bl2_n[24] bl2_n[25] bl1_n[25] bl2[25] bl1[25] bl1[26]
+ bl2[26] bl1_n[26] bl2_n[26] bl2_n[27] bl1_n[27] bl2[27] bl1[27] bl1[28]
+ bl2[28] bl1_n[28] bl2_n[28] bl2_n[29] bl1_n[29] bl2[29] bl1[29] bl1[30]
+ bl2[30] bl1_n[30] bl2_n[30] bl2_n[31] bl1_n[31] bl2[31] bl1[31] wl1[61]
+ wl2[61] wl1[60] wl2[62] wl1[62] wl2[60] wl1[63] wl2[63] wl2[59] wl1[56]
+ wl2[50] wl2[55] wl1[55] wl1[54] wl2[54] wl2[53] wl1[53] wl1[52] wl2[52]
+ wl2[51] wl1[51] wl1[50] wl1[59] wl2[49] wl1[49] wl1[48] wl2[56] wl2[48] vdd
+ wl1[57] wl2[57] wl2[58] wl1[58] DP8TArray_32X32
.ENDS DP8TArray_64X32

.SUBCKT DP8TPrecharge_bl1 precharge_n vdd bl bl_n \$6
M$1 vdd precharge_n bl \$6 sg13_lv_pmos L=0.13u W=0.5u AS=0.3775p AD=0.3p
+ PS=2.51u PD=1.7u
M$2 bl precharge_n bl_n \$6 sg13_lv_pmos L=0.13u W=0.5u AS=0.3p AD=0.3p PS=1.7u
+ PD=1.7u
M$3 bl_n precharge_n vdd \$6 sg13_lv_pmos L=0.13u W=0.5u AS=0.3p AD=0.3775p
+ PS=1.7u PD=2.51u
.ENDS DP8TPrecharge_bl1

.SUBCKT DP8TColMux_4C_bl1 muxbl bl[0] bl_n[0] muxbl_n bl_n[1] bl[1] bl[2]
+ bl_n[2] bl_n[3] bl[3] mux[0] vss mux[1] mux[2] mux[3]
M$1 bl[1] mux[1] muxbl vss sg13_lv_nmos L=0.13u W=3.5u AS=1.19p AD=0.665p
+ PS=7.68u PD=3.88u
M$2 muxbl mux[2] bl[2] vss sg13_lv_nmos L=0.13u W=3.5u AS=0.665p AD=1.19p
+ PS=3.88u PD=7.68u
M$3 bl[3] mux[3] muxbl vss sg13_lv_nmos L=0.13u W=3.5u AS=1.19p AD=1.19p
+ PS=7.68u PD=7.68u
M$4 bl_n[0] mux[0] muxbl_n vss sg13_lv_nmos L=0.13u W=3.5u AS=1.19p AD=0.665p
+ PS=7.68u PD=3.88u
M$5 muxbl_n mux[1] bl_n[1] vss sg13_lv_nmos L=0.13u W=3.5u AS=0.665p AD=1.19p
+ PS=3.88u PD=7.68u
M$6 bl_n[2] mux[2] muxbl_n vss sg13_lv_nmos L=0.13u W=3.5u AS=1.19p AD=0.665p
+ PS=7.68u PD=3.88u
M$7 muxbl_n mux[3] bl_n[3] vss sg13_lv_nmos L=0.13u W=3.5u AS=0.665p AD=1.19p
+ PS=3.88u PD=7.68u
M$8 muxbl mux[0] bl[0] vss sg13_lv_nmos L=0.13u W=3.5u AS=1.19p AD=1.19p
+ PS=7.68u PD=7.68u
.ENDS DP8TColMux_4C_bl1

.SUBCKT DP8TReadWrite_4M bl vss bl_n vdd q d clk we_n
X$1 q vdd vss bl_n bl nsnrlatch_x1
X$2 vss vdd \$5 \$16 we_n nor2_x0
X$3 vss vdd \$16 \$12 inv_x0
X$4 vss d \$12 clk vdd dff_x1
X$5 vss vdd \$3 \$12 we_n nor2_x0
M$1 bl \$3 vss vss sg13_lv_nmos L=0.13u W=1.9u AS=0.5074p AD=0.361p PS=4.48u
+ PD=2.28u
M$2 vss \$5 bl_n vss sg13_lv_nmos L=0.13u W=1.9u AS=0.361p AD=0.5074p PS=2.28u
+ PD=4.48u
.ENDS DP8TReadWrite_4M

.SUBCKT DP8TClockWE vss clkup we we_en we_n vdd clkdown
X$1 vss we \$9 clkdown vdd dff_x1
X$2 vdd vss clkup clkdown buf_x2
X$3 vss vdd \$9 we_n we_en nand2_x0
.ENDS DP8TClockWE

.SUBCKT DP8TWLDrive_26LN100WN26LP200WP_wl1 wl_drive vss wl_n vdd \$5 \$6
M$1 vss wl_n wl_drive \$5 sg13_lv_nmos L=0.13u W=1u AS=0.28p AD=0.28p PS=2.62u
+ PD=2.62u
M$3 vdd wl_n wl_drive \$6 sg13_lv_pmos L=0.13u W=2u AS=0.56p AD=0.56p PS=4.12u
+ PD=4.12u
.ENDS DP8TWLDrive_26LN100WN26LP200WP_wl1

.SUBCKT DP8TRowDecoderNand3X2 vss vdd wl_n[0] wl_en pd[0][0] page wl_n[1]
+ pd[0][1]
M$1 wl_n[0] wl_en \$12 vss sg13_lv_nmos L=0.13u W=0.5u AS=0.17p AD=0.11p
+ PS=1.68u PD=0.94u
M$2 \$12 pd[0][0] \$11 vss sg13_lv_nmos L=0.13u W=0.5u AS=0.11p AD=0.11p
+ PS=0.94u PD=0.94u
M$3 vss page \$11 vss sg13_lv_nmos L=0.13u W=0.5u AS=0.173p AD=0.11p PS=1.36u
+ PD=0.94u
M$4 vss page \$10 vss sg13_lv_nmos L=0.13u W=0.5u AS=0.173p AD=0.11p PS=1.36u
+ PD=0.94u
M$5 \$10 pd[0][1] \$9 vss sg13_lv_nmos L=0.13u W=0.5u AS=0.11p AD=0.11p
+ PS=0.94u PD=0.94u
M$6 \$9 wl_en wl_n[1] vss sg13_lv_nmos L=0.13u W=0.5u AS=0.11p AD=0.17p
+ PS=0.94u PD=1.68u
M$7 wl_n[0] wl_en vdd vdd sg13_lv_pmos L=0.13u W=0.5u AS=0.17p AD=0.173p
+ PS=1.68u PD=1.36u
M$8 vdd pd[0][0] wl_n[0] vdd sg13_lv_pmos L=0.13u W=0.5u AS=0.173p AD=0.11p
+ PS=1.36u PD=0.94u
M$9 wl_n[0] page vdd vdd sg13_lv_pmos L=0.13u W=0.5u AS=0.11p AD=0.173p
+ PS=0.94u PD=1.36u
M$10 vdd page wl_n[1] vdd sg13_lv_pmos L=0.13u W=0.5u AS=0.173p AD=0.11p
+ PS=1.36u PD=0.94u
M$11 wl_n[1] pd[0][1] vdd vdd sg13_lv_pmos L=0.13u W=0.5u AS=0.11p AD=0.173p
+ PS=0.94u PD=1.36u
M$12 vdd wl_en wl_n[1] vdd sg13_lv_pmos L=0.13u W=0.5u AS=0.173p AD=0.17p
+ PS=1.36u PD=1.68u
.ENDS DP8TRowDecoderNand3X2

.SUBCKT DP8TDec_and4_x1 vdd vss i0 i1 i2 i3 q
M$1 \$1 i0 \$11 vss sg13_lv_nmos L=0.13u W=0.78u AS=0.2652p AD=0.1482p PS=2.24u
+ PD=1.16u
M$2 \$11 i1 \$10 vss sg13_lv_nmos L=0.13u W=0.78u AS=0.1482p AD=0.1482p
+ PS=1.16u PD=1.16u
M$3 \$10 i2 \$9 vss sg13_lv_nmos L=0.13u W=0.78u AS=0.1482p AD=0.1482p PS=1.16u
+ PD=1.16u
M$4 \$9 i3 vss vss sg13_lv_nmos L=0.13u W=0.78u AS=0.1482p AD=0.5033p PS=1.16u
+ PD=3.21u
M$5 vss \$1 q vss sg13_lv_nmos L=0.13u W=2.8u AS=0.5033p AD=1.036p PS=3.21u
+ PD=6.34u
M$6 vdd i0 \$1 vdd sg13_lv_pmos L=0.13u W=1.2u AS=0.408p AD=0.228p PS=3.08u
+ PD=1.58u
M$7 \$1 i1 vdd vdd sg13_lv_pmos L=0.13u W=1.2u AS=0.228p AD=0.228p PS=1.58u
+ PD=1.58u
M$8 vdd i2 \$1 vdd sg13_lv_pmos L=0.13u W=1.2u AS=0.228p AD=0.228p PS=1.58u
+ PD=1.58u
M$9 vdd i3 \$1 vdd sg13_lv_pmos L=0.13u W=1.2u AS=0.79p AD=0.228p PS=4.81u
+ PD=1.58u
M$10 vdd \$1 q vdd sg13_lv_pmos L=0.13u W=4.4u AS=0.79p AD=1.628p PS=4.81u
+ PD=9.54u
.ENDS DP8TDec_and4_x1

.SUBCKT DP8TDec_and3_x1 vdd vss i0 i1 i2 q
M$1 \$1 i0 \$9 vss sg13_lv_nmos L=0.13u W=0.78u AS=0.2652p AD=0.1482p PS=2.24u
+ PD=1.16u
M$2 \$9 i1 \$8 vss sg13_lv_nmos L=0.13u W=0.78u AS=0.1482p AD=0.1482p PS=1.16u
+ PD=1.16u
M$3 \$8 i2 vss vss sg13_lv_nmos L=0.13u W=0.78u AS=0.1482p AD=0.5033p PS=1.16u
+ PD=3.21u
M$4 vss \$1 q vss sg13_lv_nmos L=0.13u W=2.8u AS=0.5033p AD=1.036p PS=3.21u
+ PD=6.34u
M$5 \$1 i0 vdd vdd sg13_lv_pmos L=0.13u W=1.2u AS=0.408p AD=0.228p PS=3.08u
+ PD=1.58u
M$6 vdd i1 \$1 vdd sg13_lv_pmos L=0.13u W=1.2u AS=0.228p AD=0.228p PS=1.58u
+ PD=1.58u
M$7 vdd i2 \$1 vdd sg13_lv_pmos L=0.13u W=1.2u AS=0.79p AD=0.228p PS=4.81u
+ PD=1.58u
M$8 vdd \$1 q vdd sg13_lv_pmos L=0.13u W=4.4u AS=0.79p AD=1.628p PS=4.81u
+ PD=9.54u
.ENDS DP8TDec_and3_x1

.SUBCKT DP8TDec_inv_x1 vss vdd nq i
M$1 vss i nq vss sg13_lv_nmos L=0.13u W=2.8u AS=0.952p AD=0.952p PS=6.28u
+ PD=6.28u
M$2 vdd i nq vdd sg13_lv_pmos L=0.13u W=4.4u AS=1.496p AD=1.496p PS=9.48u
+ PD=9.48u
.ENDS DP8TDec_inv_x1

.SUBCKT DP8TDec_dff_x1 vss i q clk vdd
M$1 \$4 i vss vss sg13_lv_nmos L=0.13u W=0.78u AS=0.2652p AD=0.1482p PS=2.24u
+ PD=1.16u
M$2 vss \$4 \$11 vss sg13_lv_nmos L=0.13u W=0.78u AS=0.1482p AD=0.1482p
+ PS=1.16u PD=1.16u
M$3 \$11 \$2 \$6 vss sg13_lv_nmos L=0.13u W=0.78u AS=0.1482p AD=0.1482p
+ PS=1.16u PD=1.16u
M$4 \$6 \$3 \$12 vss sg13_lv_nmos L=0.13u W=0.78u AS=0.1482p AD=0.1482p
+ PS=1.16u PD=1.16u
M$5 \$12 \$7 vss vss sg13_lv_nmos L=0.13u W=0.78u AS=0.1482p AD=0.1638p
+ PS=1.16u PD=1.2u
M$6 vss \$6 \$7 vss sg13_lv_nmos L=0.13u W=0.78u AS=0.1638p AD=0.2496p PS=1.2u
+ PD=1.42u
M$7 \$7 \$3 \$8 vss sg13_lv_nmos L=0.13u W=0.78u AS=0.2496p AD=0.1482p PS=1.42u
+ PD=1.16u
M$8 \$8 \$2 \$10 vss sg13_lv_nmos L=0.13u W=0.78u AS=0.1482p AD=0.1482p
+ PS=1.16u PD=1.16u
M$9 \$10 q vss vss sg13_lv_nmos L=0.13u W=0.78u AS=0.1482p AD=0.7217p PS=1.16u
+ PD=2.88u
M$10 vss \$8 q vss sg13_lv_nmos L=0.13u W=2.17u AS=0.7217p AD=0.7378p PS=2.88u
+ PD=5.02u
M$11 \$2 clk vss vss sg13_lv_nmos L=0.13u W=0.78u AS=0.2652p AD=0.1716p
+ PS=2.24u PD=1.22u
M$12 vss \$2 \$3 vss sg13_lv_nmos L=0.13u W=0.78u AS=0.1716p AD=0.2652p
+ PS=1.22u PD=2.24u
M$13 \$2 clk vdd vdd sg13_lv_pmos L=0.13u W=1.2u AS=0.408p AD=0.264p PS=3.08u
+ PD=1.64u
M$14 vdd \$2 \$3 vdd sg13_lv_pmos L=0.13u W=1.2u AS=0.264p AD=0.408p PS=1.64u
+ PD=3.08u
M$15 \$4 i vdd vdd sg13_lv_pmos L=0.13u W=1.2u AS=0.408p AD=0.228p PS=3.08u
+ PD=1.58u
M$16 vdd \$4 \$15 vdd sg13_lv_pmos L=0.13u W=1.2u AS=0.228p AD=0.228p PS=1.58u
+ PD=1.58u
M$17 \$15 \$3 \$6 vdd sg13_lv_pmos L=0.13u W=1.2u AS=0.228p AD=0.228p PS=1.58u
+ PD=1.58u
M$18 \$6 \$2 \$16 vdd sg13_lv_pmos L=0.13u W=1.2u AS=0.228p AD=0.228p PS=1.58u
+ PD=1.58u
M$19 \$16 \$7 vdd vdd sg13_lv_pmos L=0.13u W=1.2u AS=0.228p AD=0.252p PS=1.58u
+ PD=1.62u
M$20 vdd \$6 \$7 vdd sg13_lv_pmos L=0.13u W=1.2u AS=0.252p AD=0.384p PS=1.62u
+ PD=1.84u
M$21 \$7 \$2 \$8 vdd sg13_lv_pmos L=0.13u W=1.2u AS=0.384p AD=0.228p PS=1.84u
+ PD=1.58u
M$22 \$8 \$3 \$17 vdd sg13_lv_pmos L=0.13u W=1.2u AS=0.228p AD=0.228p PS=1.58u
+ PD=1.58u
M$23 vdd q \$17 vdd sg13_lv_pmos L=0.13u W=1.2u AS=1.2484p AD=0.228p PS=4.48u
+ PD=1.58u
M$24 vdd \$8 q vdd sg13_lv_pmos L=0.13u W=3.77u AS=1.2484p AD=1.2818p PS=4.48u
+ PD=8.22u
.ENDS DP8TDec_dff_x1

.SUBCKT DP8TArray_32X32 vss bl1[0] bl2[0] bl1_n[0] bl2_n[0] bl2_n[1] bl1_n[1]
+ bl2[1] bl1[1] bl1[2] bl2[2] bl1_n[2] bl2_n[2] bl2_n[3] bl1_n[3] bl2[3] bl1[3]
+ bl1[4] bl2[4] bl1_n[4] bl2_n[4] bl2_n[5] bl1_n[5] bl2[5] bl1[5] bl1[6] bl2[6]
+ bl1_n[6] bl2_n[6] bl2_n[7] bl1_n[7] bl2[7] bl1[7] bl1[8] bl2[8] bl1_n[8]
+ bl2_n[8] bl2_n[9] bl1_n[9] bl2[9] bl1[9] bl1[10] bl2[10] bl1_n[10] bl2_n[10]
+ bl2_n[11] bl1_n[11] bl2[11] bl1[11] bl1[12] bl2[12] bl1_n[12] bl2_n[12]
+ bl2_n[13] bl1_n[13] bl2[13] bl1[13] bl1[14] bl2[14] bl1_n[14] bl2_n[14]
+ bl2_n[15] bl1_n[15] bl2[15] bl1[15] wl1[10] wl2[5] wl2[10] wl2[9] wl1[9]
+ wl1[8] wl1[11] wl2[11] wl2[12] wl1[12] wl1[13] wl2[13] wl2[14] wl1[14]
+ wl1[15] wl2[15] wl2[8] wl1[2] wl2[2] wl1[3] wl2[1] wl2[3] wl1[1] wl2[4]
+ wl1[0] wl1[4] wl2[0] wl1[5] wl2[6] wl1[6] wl1[7] wl2[7] bl1[16] bl2[16]
+ bl1_n[16] bl2_n[16] bl2_n[17] bl1_n[17] bl2[17] bl1[17] bl1[18] bl2[18]
+ bl1_n[18] bl2_n[18] bl2_n[19] bl1_n[19] bl2[19] bl1[19] bl1[20] bl2[20]
+ bl1_n[20] bl2_n[20] bl2_n[21] bl1_n[21] bl2[21] bl1[21] bl1[22] bl2[22]
+ bl1_n[22] bl2_n[22] bl2_n[23] bl1_n[23] bl2[23] bl1[23] bl1[24] bl2[24]
+ bl1_n[24] bl2_n[24] bl2_n[25] bl1_n[25] bl2[25] bl1[25] bl1[26] bl2[26]
+ bl1_n[26] bl2_n[26] bl2_n[27] bl1_n[27] bl2[27] bl1[27] bl1[28] bl2[28]
+ bl1_n[28] bl2_n[28] bl2_n[29] bl1_n[29] bl2[29] bl1[29] bl1[30] bl2[30]
+ bl1_n[30] bl2_n[30] bl2_n[31] bl1_n[31] bl2[31] bl1[31] wl1[29] wl2[29]
+ wl1[28] wl2[30] wl1[30] wl2[28] wl1[31] wl2[31] wl2[27] wl1[24] wl2[18]
+ wl2[23] wl1[23] wl1[22] wl2[22] wl2[21] wl1[21] wl1[20] wl2[20] wl2[19]
+ wl1[19] wl1[18] wl1[27] wl2[17] wl1[17] wl1[16] wl2[24] wl2[16] vdd wl1[25]
+ wl2[25] wl2[26] wl1[26]
X$1 vss vdd bl1[0] vss bl2[0] vdd bl1_n[0] bl2_n[0] bl2_n[1] bl1_n[1] bl2[1]
+ bl1[1] bl1[2] bl2[2] bl1_n[2] bl2_n[2] bl2_n[3] bl1_n[3] bl2[3] bl1[3] bl1[4]
+ bl2[4] bl1_n[4] bl2_n[4] bl2_n[5] bl1_n[5] bl2[5] bl1[5] bl1[6] bl2[6]
+ bl1_n[6] bl2_n[6] bl2_n[7] bl1_n[7] bl2[7] bl1[7] bl1[8] bl2[8] bl1_n[8]
+ bl2_n[8] bl2_n[9] bl1_n[9] bl2[9] bl1[9] bl1[10] bl2[10] bl1_n[10] bl2_n[10]
+ bl2_n[11] bl1_n[11] bl2[11] bl1[11] bl1[12] bl2[12] bl1_n[12] bl2_n[12]
+ bl2_n[13] bl1_n[13] bl2[13] bl1[13] bl1[14] bl2[14] bl1_n[14] bl2_n[14]
+ bl2_n[15] bl1_n[15] bl2[15] bl1[15] wl2[0] wl2[1] wl1[1] wl2[7] wl1[7] wl2[4]
+ wl1[4] wl2[3] wl1[3] wl2[2] wl1[6] wl2[5] wl1[5] wl2[6] wl1[0] wl1[2] bl1[16]
+ bl2[16] bl1_n[16] bl2_n[16] bl2_n[17] bl1_n[17] bl2[17] bl1[17] bl1[18]
+ bl2[18] bl1_n[18] bl2_n[18] bl2_n[19] bl1_n[19] bl2[19] bl1[19] bl1[20]
+ bl2[20] bl1_n[20] bl2_n[20] bl2_n[21] bl1_n[21] bl2[21] bl1[21] bl1[22]
+ bl2[22] bl1_n[22] bl2_n[22] bl2_n[23] bl1_n[23] bl2[23] bl1[23] bl1[24]
+ bl2[24] bl1_n[24] bl2_n[24] bl2_n[25] bl1_n[25] bl2[25] bl1[25] bl1[26]
+ bl2[26] bl1_n[26] bl2_n[26] bl2_n[27] bl1_n[27] bl2[27] bl1[27] bl1[28]
+ bl2[28] bl1_n[28] bl2_n[28] bl2_n[29] bl1_n[29] bl2[29] bl1[29] bl1[30]
+ bl2[30] bl1_n[30] bl2_n[30] bl2_n[31] bl1_n[31] bl2[31] bl1[31] wl1[10]
+ wl2[12] wl1[9] wl2[9] wl2[10] wl1[14] wl2[11] wl2[14] wl1[11] wl1[12] wl2[13]
+ wl1[13] wl2[15] wl1[15] wl2[8] wl1[8] DP8TArray_16X32
X$3 vss vdd bl1[0] vss bl2[0] vdd bl1_n[0] bl2_n[0] bl2_n[1] bl1_n[1] bl2[1]
+ bl1[1] bl1[2] bl2[2] bl1_n[2] bl2_n[2] bl2_n[3] bl1_n[3] bl2[3] bl1[3] bl1[4]
+ bl2[4] bl1_n[4] bl2_n[4] bl2_n[5] bl1_n[5] bl2[5] bl1[5] bl1[6] bl2[6]
+ bl1_n[6] bl2_n[6] bl2_n[7] bl1_n[7] bl2[7] bl1[7] bl1[8] bl2[8] bl1_n[8]
+ bl2_n[8] bl2_n[9] bl1_n[9] bl2[9] bl1[9] bl1[10] bl2[10] bl1_n[10] bl2_n[10]
+ bl2_n[11] bl1_n[11] bl2[11] bl1[11] bl1[12] bl2[12] bl1_n[12] bl2_n[12]
+ bl2_n[13] bl1_n[13] bl2[13] bl1[13] bl1[14] bl2[14] bl1_n[14] bl2_n[14]
+ bl2_n[15] bl1_n[15] bl2[15] bl1[15] wl2[16] wl2[17] wl1[17] wl2[23] wl1[23]
+ wl2[20] wl1[20] wl2[19] wl1[19] wl2[18] wl1[22] wl2[21] wl1[21] wl2[22]
+ wl1[16] wl1[18] bl1[16] bl2[16] bl1_n[16] bl2_n[16] bl2_n[17] bl1_n[17]
+ bl2[17] bl1[17] bl1[18] bl2[18] bl1_n[18] bl2_n[18] bl2_n[19] bl1_n[19]
+ bl2[19] bl1[19] bl1[20] bl2[20] bl1_n[20] bl2_n[20] bl2_n[21] bl1_n[21]
+ bl2[21] bl1[21] bl1[22] bl2[22] bl1_n[22] bl2_n[22] bl2_n[23] bl1_n[23]
+ bl2[23] bl1[23] bl1[24] bl2[24] bl1_n[24] bl2_n[24] bl2_n[25] bl1_n[25]
+ bl2[25] bl1[25] bl1[26] bl2[26] bl1_n[26] bl2_n[26] bl2_n[27] bl1_n[27]
+ bl2[27] bl1[27] bl1[28] bl2[28] bl1_n[28] bl2_n[28] bl2_n[29] bl1_n[29]
+ bl2[29] bl1[29] bl1[30] bl2[30] bl1_n[30] bl2_n[30] bl2_n[31] bl1_n[31]
+ bl2[31] bl1[31] wl1[26] wl2[28] wl1[25] wl2[25] wl2[26] wl1[30] wl2[27]
+ wl2[30] wl1[27] wl1[28] wl2[29] wl1[29] wl2[31] wl1[31] wl2[24] wl1[24]
+ DP8TArray_16X32
.ENDS DP8TArray_32X32

.SUBCKT nor2_x0 vss vdd nq i0 i1
M$1 vss i0 nq vss sg13_lv_nmos L=0.13u W=0.78u AS=0.2652p AD=0.1482p PS=2.24u
+ PD=1.16u
M$2 nq i1 vss vss sg13_lv_nmos L=0.13u W=0.78u AS=0.1482p AD=0.2808p PS=1.16u
+ PD=2.28u
M$3 vdd i0 \$6 vdd sg13_lv_pmos L=0.13u W=0.78u AS=0.2652p AD=0.1482p PS=2.24u
+ PD=1.16u
M$4 \$6 i1 nq vdd sg13_lv_pmos L=0.13u W=0.78u AS=0.1482p AD=0.2808p PS=1.16u
+ PD=2.28u
.ENDS nor2_x0

.SUBCKT nsnrlatch_x1 q vdd vss nset nrst
M$1 q nset \$8 vss sg13_lv_nmos L=0.13u W=1.31u AS=0.4454p AD=0.2489p PS=3.3u
+ PD=1.69u
M$2 \$8 nq vss vss sg13_lv_nmos L=0.13u W=1.31u AS=0.2489p AD=0.2489p PS=1.69u
+ PD=1.69u
M$3 vss q \$7 vss sg13_lv_nmos L=0.13u W=1.31u AS=0.2489p AD=0.262p PS=1.69u
+ PD=1.71u
M$4 \$7 nrst nq vss sg13_lv_nmos L=0.13u W=1.31u AS=0.262p AD=0.4454p PS=1.71u
+ PD=3.3u
M$5 vdd nset q vdd sg13_lv_pmos L=0.13u W=1.3u AS=0.442p AD=0.247p PS=3.28u
+ PD=1.68u
M$6 q nq vdd vdd sg13_lv_pmos L=0.13u W=1.3u AS=0.247p AD=0.247p PS=1.68u
+ PD=1.68u
M$7 vdd q nq vdd sg13_lv_pmos L=0.13u W=1.3u AS=0.247p AD=0.26p PS=1.68u PD=1.7u
M$8 nq nrst vdd vdd sg13_lv_pmos L=0.13u W=1.3u AS=0.26p AD=0.442p PS=1.7u
+ PD=3.28u
.ENDS nsnrlatch_x1

.SUBCKT dff_x1 vss i q clk vdd
M$1 \$4 i vss vss sg13_lv_nmos L=0.13u W=0.78u AS=0.2652p AD=0.1482p PS=2.24u
+ PD=1.16u
M$2 vss \$4 \$12 vss sg13_lv_nmos L=0.13u W=0.78u AS=0.1482p AD=0.1482p
+ PS=1.16u PD=1.16u
M$3 \$12 \$2 \$6 vss sg13_lv_nmos L=0.13u W=0.78u AS=0.1482p AD=0.1482p
+ PS=1.16u PD=1.16u
M$4 \$6 \$3 \$11 vss sg13_lv_nmos L=0.13u W=0.78u AS=0.1482p AD=0.1482p
+ PS=1.16u PD=1.16u
M$5 \$11 \$7 vss vss sg13_lv_nmos L=0.13u W=0.78u AS=0.1482p AD=0.1482p
+ PS=1.16u PD=1.16u
M$6 vss \$6 \$7 vss sg13_lv_nmos L=0.13u W=0.78u AS=0.1482p AD=0.2028p PS=1.16u
+ PD=1.3u
M$7 \$7 \$3 \$8 vss sg13_lv_nmos L=0.13u W=0.78u AS=0.2028p AD=0.1482p PS=1.3u
+ PD=1.16u
M$8 \$8 \$2 \$10 vss sg13_lv_nmos L=0.13u W=0.78u AS=0.1482p AD=0.1482p
+ PS=1.16u PD=1.16u
M$9 \$10 q vss vss sg13_lv_nmos L=0.13u W=0.78u AS=0.1482p AD=0.2265p PS=1.16u
+ PD=1.38u
M$10 vss \$8 q vss sg13_lv_nmos L=0.13u W=0.83u AS=0.2265p AD=0.2822p PS=1.38u
+ PD=2.34u
M$11 \$2 clk vss vss sg13_lv_nmos L=0.13u W=0.78u AS=0.2652p AD=0.156p PS=2.24u
+ PD=1.18u
M$12 vss \$2 \$3 vss sg13_lv_nmos L=0.13u W=0.78u AS=0.156p AD=0.2652p PS=1.18u
+ PD=2.24u
M$13 \$2 clk vdd vdd sg13_lv_pmos L=0.13u W=0.78u AS=0.2652p AD=0.156p PS=2.24u
+ PD=1.18u
M$14 vdd \$2 \$3 vdd sg13_lv_pmos L=0.13u W=0.78u AS=0.156p AD=0.2652p PS=1.18u
+ PD=2.24u
M$15 \$4 i vdd vdd sg13_lv_pmos L=0.13u W=0.78u AS=0.2652p AD=0.1482p PS=2.24u
+ PD=1.16u
M$16 vdd \$4 \$15 vdd sg13_lv_pmos L=0.13u W=0.78u AS=0.1482p AD=0.1482p
+ PS=1.16u PD=1.16u
M$17 \$15 \$3 \$6 vdd sg13_lv_pmos L=0.13u W=0.78u AS=0.1482p AD=0.1482p
+ PS=1.16u PD=1.16u
M$18 \$6 \$2 \$16 vdd sg13_lv_pmos L=0.13u W=0.78u AS=0.1482p AD=0.1482p
+ PS=1.16u PD=1.16u
M$19 \$16 \$7 vdd vdd sg13_lv_pmos L=0.13u W=0.78u AS=0.1482p AD=0.1482p
+ PS=1.16u PD=1.16u
M$20 vdd \$6 \$7 vdd sg13_lv_pmos L=0.13u W=0.78u AS=0.1482p AD=0.2028p
+ PS=1.16u PD=1.3u
M$21 \$7 \$2 \$8 vdd sg13_lv_pmos L=0.13u W=0.78u AS=0.2028p AD=0.1482p PS=1.3u
+ PD=1.16u
M$22 \$8 \$3 \$17 vdd sg13_lv_pmos L=0.13u W=0.78u AS=0.1482p AD=0.1482p
+ PS=1.16u PD=1.16u
M$23 vdd q \$17 vdd sg13_lv_pmos L=0.13u W=0.78u AS=0.2241p AD=0.1482p PS=1.37u
+ PD=1.16u
M$24 vdd \$8 q vdd sg13_lv_pmos L=0.13u W=0.82u AS=0.2241p AD=0.2788p PS=1.37u
+ PD=2.32u
.ENDS dff_x1

.SUBCKT buf_x2 vdd vss i q
M$1 \$1 i vss vss sg13_lv_nmos L=0.13u W=0.78u AS=0.2652p AD=0.2092p PS=2.24u
+ PD=1.48u
M$2 vss \$1 q vss sg13_lv_nmos L=0.13u W=2.14u AS=0.4125p AD=0.5671p PS=2.93u
+ PD=4.27u
M$4 vdd i \$1 vdd sg13_lv_pmos L=0.13u W=0.78u AS=0.2075p AD=0.2652p PS=1.47u
+ PD=2.24u
M$5 vdd \$1 q vdd sg13_lv_pmos L=0.13u W=2.12u AS=0.4089p AD=0.5618p PS=2.91u
+ PD=4.24u
.ENDS buf_x2

.SUBCKT nand2_x0 vss vdd i0 nq i1
M$1 vss i0 \$6 vss sg13_lv_nmos L=0.13u W=0.78u AS=0.2652p AD=0.1482p PS=2.24u
+ PD=1.16u
M$2 \$6 i1 nq vss sg13_lv_nmos L=0.13u W=0.78u AS=0.1482p AD=0.2808p PS=1.16u
+ PD=2.28u
M$3 vdd i0 nq vdd sg13_lv_pmos L=0.13u W=0.78u AS=0.2652p AD=0.1482p PS=2.24u
+ PD=1.16u
M$4 nq i1 vdd vdd sg13_lv_pmos L=0.13u W=0.78u AS=0.1482p AD=0.2808p PS=1.16u
+ PD=2.28u
.ENDS nand2_x0

.SUBCKT inv_x0 vss vdd nq i
M$1 vss i nq vss sg13_lv_nmos L=0.13u W=0.78u AS=0.2652p AD=0.2652p PS=2.24u
+ PD=2.24u
M$2 vdd i nq vdd sg13_lv_pmos L=0.13u W=0.78u AS=0.2652p AD=0.2652p PS=2.24u
+ PD=2.24u
.ENDS inv_x0

.SUBCKT DP8TArray_16X32 \$1 nwell bl1[0] vss bl2[0] vdd bl1_n[0] bl2_n[0]
+ bl2_n[1] bl1_n[1] bl2[1] bl1[1] bl1[2] bl2[2] bl1_n[2] bl2_n[2] bl2_n[3]
+ bl1_n[3] bl2[3] bl1[3] bl1[4] bl2[4] bl1_n[4] bl2_n[4] bl2_n[5] bl1_n[5]
+ bl2[5] bl1[5] bl1[6] bl2[6] bl1_n[6] bl2_n[6] bl2_n[7] bl1_n[7] bl2[7] bl1[7]
+ bl1[8] bl2[8] bl1_n[8] bl2_n[8] bl2_n[9] bl1_n[9] bl2[9] bl1[9] bl1[10]
+ bl2[10] bl1_n[10] bl2_n[10] bl2_n[11] bl1_n[11] bl2[11] bl1[11] bl1[12]
+ bl2[12] bl1_n[12] bl2_n[12] bl2_n[13] bl1_n[13] bl2[13] bl1[13] bl1[14]
+ bl2[14] bl1_n[14] bl2_n[14] bl2_n[15] bl1_n[15] bl2[15] bl1[15] wl2[0] wl2[1]
+ wl1[1] wl2[7] wl1[7] wl2[4] wl1[4] wl2[3] wl1[3] wl2[2] wl1[6] wl2[5] wl1[5]
+ wl2[6] wl1[0] wl1[2] bl1[16] bl2[16] bl1_n[16] bl2_n[16] bl2_n[17] bl1_n[17]
+ bl2[17] bl1[17] bl1[18] bl2[18] bl1_n[18] bl2_n[18] bl2_n[19] bl1_n[19]
+ bl2[19] bl1[19] bl1[20] bl2[20] bl1_n[20] bl2_n[20] bl2_n[21] bl1_n[21]
+ bl2[21] bl1[21] bl1[22] bl2[22] bl1_n[22] bl2_n[22] bl2_n[23] bl1_n[23]
+ bl2[23] bl1[23] bl1[24] bl2[24] bl1_n[24] bl2_n[24] bl2_n[25] bl1_n[25]
+ bl2[25] bl1[25] bl1[26] bl2[26] bl1_n[26] bl2_n[26] bl2_n[27] bl1_n[27]
+ bl2[27] bl1[27] bl1[28] bl2[28] bl1_n[28] bl2_n[28] bl2_n[29] bl1_n[29]
+ bl2[29] bl1[29] bl1[30] bl2[30] bl1_n[30] bl2_n[30] bl2_n[31] bl1_n[31]
+ bl2[31] bl1[31] wl1[10] wl2[12] wl1[9] wl2[9] wl2[10] wl1[14] wl2[11] wl2[14]
+ wl1[11] wl1[12] wl2[13] wl1[13] wl2[15] wl1[15] wl2[8] wl1[8]
X$1 \$1 nwell vss wl1[1] wl2[0] wl2[1] wl2[2] wl1[2] wl1[3] wl2[3] wl2[4]
+ wl1[4] wl1[5] wl2[5] wl2[6] wl1[6] wl1[0] bl1[16] bl2[16] vdd bl1_n[16]
+ bl2_n[16] bl2_n[17] bl1_n[17] bl2[17] bl1[17] bl1[18] bl2[18] bl1_n[18]
+ bl2_n[18] bl2_n[19] bl1_n[19] bl2[19] bl1[19] bl1[20] bl2[20] bl1_n[20]
+ bl2_n[20] bl2_n[21] bl1_n[21] bl2[21] bl1[21] bl1[22] bl2[22] bl1_n[22]
+ bl2_n[22] bl2_n[23] bl1_n[23] bl2[23] bl1[23] wl2[7] wl1[9] wl2[9] wl1[7]
+ wl2[8] wl1[8] bl1[24] bl2[24] bl1_n[24] bl2_n[24] bl2_n[25] bl1_n[25] bl2[25]
+ bl1[25] bl1[26] bl2[26] bl1_n[26] bl2_n[26] bl2_n[27] bl1_n[27] bl2[27]
+ bl1[27] bl1[28] bl2[28] bl1_n[28] bl2_n[28] bl2_n[29] bl1_n[29] bl2[29]
+ bl1[29] bl1[30] bl2[30] bl1_n[30] bl2_n[30] bl2_n[31] bl1_n[31] bl2[31]
+ bl1[31] wl1[11] wl2[11] wl2[12] wl1[12] wl1[13] wl2[13] wl1[10] wl1[15]
+ wl2[14] wl2[10] wl1[14] wl2[15] DP8TArray_16X16
X$2 \$1 nwell vss wl1[1] wl2[0] wl2[1] wl2[2] wl1[2] wl1[3] wl2[3] wl2[4]
+ wl1[4] wl1[5] wl2[5] wl2[6] wl1[6] wl1[0] bl1[0] bl2[0] vdd bl1_n[0] bl2_n[0]
+ bl2_n[1] bl1_n[1] bl2[1] bl1[1] bl1[2] bl2[2] bl1_n[2] bl2_n[2] bl2_n[3]
+ bl1_n[3] bl2[3] bl1[3] bl1[4] bl2[4] bl1_n[4] bl2_n[4] bl2_n[5] bl1_n[5]
+ bl2[5] bl1[5] bl1[6] bl2[6] bl1_n[6] bl2_n[6] bl2_n[7] bl1_n[7] bl2[7] bl1[7]
+ wl2[7] wl1[9] wl2[9] wl1[7] wl2[8] wl1[8] bl1[8] bl2[8] bl1_n[8] bl2_n[8]
+ bl2_n[9] bl1_n[9] bl2[9] bl1[9] bl1[10] bl2[10] bl1_n[10] bl2_n[10] bl2_n[11]
+ bl1_n[11] bl2[11] bl1[11] bl1[12] bl2[12] bl1_n[12] bl2_n[12] bl2_n[13]
+ bl1_n[13] bl2[13] bl1[13] bl1[14] bl2[14] bl1_n[14] bl2_n[14] bl2_n[15]
+ bl1_n[15] bl2[15] bl1[15] wl1[11] wl2[11] wl2[12] wl1[12] wl1[13] wl2[13]
+ wl1[10] wl1[15] wl2[14] wl2[10] wl1[14] wl2[15] DP8TArray_16X16
.ENDS DP8TArray_16X32

.SUBCKT DP8TArray_16X16 \$1 nwell vss wl1[1] wl2[0] wl2[1] wl2[2] wl1[2] wl1[3]
+ wl2[3] wl2[4] wl1[4] wl1[5] wl2[5] wl2[6] wl1[6] wl1[0] bl1[0] bl2[0] vdd
+ bl1_n[0] bl2_n[0] bl2_n[1] bl1_n[1] bl2[1] bl1[1] bl1[2] bl2[2] bl1_n[2]
+ bl2_n[2] bl2_n[3] bl1_n[3] bl2[3] bl1[3] bl1[4] bl2[4] bl1_n[4] bl2_n[4]
+ bl2_n[5] bl1_n[5] bl2[5] bl1[5] bl1[6] bl2[6] bl1_n[6] bl2_n[6] bl2_n[7]
+ bl1_n[7] bl2[7] bl1[7] wl2[7] wl1[9] wl2[9] wl1[7] wl2[8] wl1[8] bl1[8]
+ bl2[8] bl1_n[8] bl2_n[8] bl2_n[9] bl1_n[9] bl2[9] bl1[9] bl1[10] bl2[10]
+ bl1_n[10] bl2_n[10] bl2_n[11] bl1_n[11] bl2[11] bl1[11] bl1[12] bl2[12]
+ bl1_n[12] bl2_n[12] bl2_n[13] bl1_n[13] bl2[13] bl1[13] bl1[14] bl2[14]
+ bl1_n[14] bl2_n[14] bl2_n[15] bl1_n[15] bl2[15] bl1[15] wl1[11] wl2[11]
+ wl2[12] wl1[12] wl1[13] wl2[13] wl1[10] wl1[15] wl2[14] wl2[10] wl1[14]
+ wl2[15]
X$1 \$1 vss wl2[4] wl1[4] wl2[3] wl1[0] wl1[3] wl1[2] wl2[2] wl1[5] wl2[5]
+ wl2[1] wl1[1] wl2[0] bl1[8] bl2[8] vdd bl1_n[8] bl2_n[8] bl2_n[9] bl1_n[9]
+ bl2[9] bl1[9] bl1[10] bl2[10] bl1_n[10] bl2_n[10] bl2_n[11] bl1_n[11] bl2[11]
+ bl1[11] wl1[7] wl2[7] wl1[6] wl2[6] bl1[12] bl2[12] bl1_n[12] bl2_n[12]
+ bl2_n[13] bl1_n[13] bl2[13] bl1[13] bl1[14] bl2[14] bl1_n[14] bl2_n[14]
+ bl2_n[15] bl1_n[15] bl2[15] bl1[15] wl2[10] wl1[10] wl1[11] wl2[11] wl2[12]
+ wl2[9] wl1[12] wl1[9] wl1[13] wl2[13] wl1[8] wl2[8] wl1[14] wl2[14] wl1[15]
+ wl2[15] nwell DP8TArray_16X8
X$2 \$1 vss wl2[4] wl1[4] wl2[3] wl1[0] wl1[3] wl1[2] wl2[2] wl1[5] wl2[5]
+ wl2[1] wl1[1] wl2[0] bl1[0] bl2[0] vdd bl1_n[0] bl2_n[0] bl2_n[1] bl1_n[1]
+ bl2[1] bl1[1] bl1[2] bl2[2] bl1_n[2] bl2_n[2] bl2_n[3] bl1_n[3] bl2[3] bl1[3]
+ wl1[7] wl2[7] wl1[6] wl2[6] bl1[4] bl2[4] bl1_n[4] bl2_n[4] bl2_n[5] bl1_n[5]
+ bl2[5] bl1[5] bl1[6] bl2[6] bl1_n[6] bl2_n[6] bl2_n[7] bl1_n[7] bl2[7] bl1[7]
+ wl2[10] wl1[10] wl1[11] wl2[11] wl2[12] wl2[9] wl1[12] wl1[9] wl1[13] wl2[13]
+ wl1[8] wl2[8] wl1[14] wl2[14] wl1[15] wl2[15] nwell DP8TArray_16X8
.ENDS DP8TArray_16X16

.SUBCKT DP8TArray_16X8 \$1 vss wl2[4] wl1[4] wl2[3] wl1[0] wl1[3] wl1[2] wl2[2]
+ wl1[5] wl2[5] wl2[1] wl1[1] wl2[0] bl1[0] bl2[0] vdd bl1_n[0] bl2_n[0]
+ bl2_n[1] bl1_n[1] bl2[1] bl1[1] bl1[2] bl2[2] bl1_n[2] bl2_n[2] bl2_n[3]
+ bl1_n[3] bl2[3] bl1[3] wl1[7] wl2[7] wl1[6] wl2[6] bl1[4] bl2[4] bl1_n[4]
+ bl2_n[4] bl2_n[5] bl1_n[5] bl2[5] bl1[5] bl1[6] bl2[6] bl1_n[6] bl2_n[6]
+ bl2_n[7] bl1_n[7] bl2[7] bl1[7] wl2[10] wl1[10] wl1[11] wl2[11] wl2[12]
+ wl2[9] wl1[12] wl1[9] wl1[13] wl2[13] wl1[8] wl2[8] wl1[14] wl2[14] wl1[15]
+ wl2[15] \$I2
X$1 \$1 \$I2 bl1[0] vss bl2[0] vdd bl1_n[0] bl2_n[0] bl2_n[1] bl1_n[1] bl2[1]
+ bl1[1] bl1[2] bl2[2] bl1_n[2] bl2_n[2] bl2_n[3] bl1_n[3] bl2[3] bl1[3]
+ wl2[11] wl1[11] wl2[9] wl1[9] wl2[8] wl2[10] wl1[8] wl1[10] bl1[4] bl2[4]
+ bl1_n[4] bl2_n[4] bl2_n[5] bl1_n[5] bl2[5] bl1[5] bl1[6] bl2[6] bl1_n[6]
+ bl2_n[6] bl2_n[7] bl1_n[7] bl2[7] bl1[7] wl2[13] wl1[13] wl2[12] wl1[14]
+ wl1[12] wl1[15] wl2[14] wl2[15] DP8TArray_8X8
X$2 \$1 \$I2 bl1[0] vss bl2[0] vdd bl1_n[0] bl2_n[0] bl2_n[1] bl1_n[1] bl2[1]
+ bl1[1] bl1[2] bl2[2] bl1_n[2] bl2_n[2] bl2_n[3] bl1_n[3] bl2[3] bl1[3] wl2[3]
+ wl1[3] wl2[1] wl1[1] wl2[0] wl2[2] wl1[0] wl1[2] bl1[4] bl2[4] bl1_n[4]
+ bl2_n[4] bl2_n[5] bl1_n[5] bl2[5] bl1[5] bl1[6] bl2[6] bl1_n[6] bl2_n[6]
+ bl2_n[7] bl1_n[7] bl2[7] bl1[7] wl2[5] wl1[5] wl2[4] wl1[6] wl1[4] wl1[7]
+ wl2[6] wl2[7] DP8TArray_8X8
.ENDS DP8TArray_16X8

.SUBCKT DP8TArray_8X8 \$1 nwell bl1[0] vss bl2[0] vdd bl1_n[0] bl2_n[0]
+ bl2_n[1] bl1_n[1] bl2[1] bl1[1] bl1[2] bl2[2] bl1_n[2] bl2_n[2] bl2_n[3]
+ bl1_n[3] bl2[3] bl1[3] wl2[3] wl1[3] wl2[1] wl1[1] wl2[0] wl2[2] wl1[0]
+ wl1[2] bl1[4] bl2[4] bl1_n[4] bl2_n[4] bl2_n[5] bl1_n[5] bl2[5] bl1[5] bl1[6]
+ bl2[6] bl1_n[6] bl2_n[6] bl2_n[7] bl1_n[7] bl2[7] bl1[7] wl2[5] wl1[5] wl2[4]
+ wl1[6] wl1[4] wl1[7] wl2[6] wl2[7]
X$1 \$1 bl1[4] vss bl2[4] vdd bl1_n[4] bl2_n[4] bl2_n[5] bl1_n[5] bl2[5] bl1[5]
+ wl2[1] wl2[3] wl1[0] wl1[3] wl2[0] wl1[2] wl2[2] wl1[1] bl1[6] bl2[6]
+ bl1_n[6] bl2_n[6] bl2_n[7] bl1_n[7] bl2[7] bl1[7] wl2[6] wl2[4] wl1[4] wl1[5]
+ wl2[5] wl1[6] wl1[7] wl2[7] nwell DP8TArray_8X4
X$2 \$1 bl1[0] vss bl2[0] vdd bl1_n[0] bl2_n[0] bl2_n[1] bl1_n[1] bl2[1] bl1[1]
+ wl2[1] wl2[3] wl1[0] wl1[3] wl2[0] wl1[2] wl2[2] wl1[1] bl1[2] bl2[2]
+ bl1_n[2] bl2_n[2] bl2_n[3] bl1_n[3] bl2[3] bl1[3] wl2[6] wl2[4] wl1[4] wl1[5]
+ wl2[5] wl1[6] wl1[7] wl2[7] nwell DP8TArray_8X4
.ENDS DP8TArray_8X8

.SUBCKT DP8TArray_8X4 \$1 bl1[0] vss bl2[0] vdd bl1_n[0] bl2_n[0] bl2_n[1]
+ bl1_n[1] bl2[1] bl1[1] wl2[1] wl2[3] wl1[0] wl1[3] wl2[0] wl1[2] wl2[2]
+ wl1[1] bl1[2] bl2[2] bl1_n[2] bl2_n[2] bl2_n[3] bl1_n[3] bl2[3] bl1[3] wl2[6]
+ wl2[4] wl1[4] wl1[5] wl2[5] wl1[6] wl1[7] wl2[7] \$I30
X$1 \$1 vss vdd bl1[0] bl1_n[0] bl2[0] bl2_n[0] bl1[1] bl1_n[1] bl2[1] bl2_n[1]
+ bl1[2] bl1_n[2] bl2[2] bl2_n[2] bl1[3] bl1_n[3] bl2[3] bl2_n[3] wl1[4] wl2[4]
+ wl1[5] wl2[5] wl1[6] wl2[6] wl1[7] wl2[7] \$I30 DP8TArray_4X4
X$2 \$1 vss vdd bl1[0] bl1_n[0] bl2[0] bl2_n[0] bl1[1] bl1_n[1] bl2[1] bl2_n[1]
+ bl1[2] bl1_n[2] bl2[2] bl2_n[2] bl1[3] bl1_n[3] bl2[3] bl2_n[3] wl1[0] wl2[0]
+ wl1[1] wl2[1] wl1[2] wl2[2] wl1[3] wl2[3] \$I30 DP8TArray_4X4
.ENDS DP8TArray_8X4

.SUBCKT DP8TArray_4X4 \$1 vss vdd bl1[0] bl1_n[0] bl2[0] bl2_n[0] bl1[1]
+ bl1_n[1] bl2[1] bl2_n[1] bl1[2] bl1_n[2] bl2[2] bl2_n[2] bl1[3] bl1_n[3]
+ bl2[3] bl2_n[3] wl1[0] wl2[0] wl1[1] wl2[1] wl1[2] wl2[2] wl1[3] wl2[3] nwell
X$1 \$1 vss vdd bl1[2] bl1_n[2] bl2[2] bl2_n[2] bl1[3] bl1_n[3] bl2[3] bl2_n[3]
+ wl1[0] wl2[0] wl1[1] wl2[1] wl1[2] wl2[2] wl1[3] wl2[3] nwell DP8TArray_4X2
X$2 \$1 vss vdd bl1[0] bl1_n[0] bl2[0] bl2_n[0] bl1[1] bl1_n[1] bl2[1] bl2_n[1]
+ wl1[0] wl2[0] wl1[1] wl2[1] wl1[2] wl2[2] wl1[3] wl2[3] nwell DP8TArray_4X2
.ENDS DP8TArray_4X4

.SUBCKT DP8TArray_4X2 \$1 vss vdd bl1[0] bl1_n[0] bl2[0] bl2_n[0] bl1[1]
+ bl1_n[1] bl2[1] bl2_n[1] wl1[0] wl2[0] wl1[1] wl2[1] wl1[2] wl2[2] wl1[3]
+ wl2[3] \$I16
X$1 \$1 vss vdd bl1[0] bl1_n[0] bl2[0] bl2_n[0] bl1[1] bl1_n[1] bl2[1] bl2_n[1]
+ wl1[2] wl2[2] wl1[3] wl2[3] \$I16 DP8TArray_2X2
X$2 \$1 vss vdd bl1[0] bl1_n[0] bl2[0] bl2_n[0] bl1[1] bl1_n[1] bl2[1] bl2_n[1]
+ wl1[0] wl2[0] wl1[1] wl2[1] \$I16 DP8TArray_2X2
.ENDS DP8TArray_4X2

.SUBCKT DP8TArray_2X2 \$1 vss vdd bl1[0] bl1_n[0] bl2[0] bl2_n[0] bl1[1]
+ bl1_n[1] bl2[1] bl2_n[1] wl1[0] wl2[0] wl1[1] wl2[1] nwell
X$1 \$1 vss vdd bl1[1] bl1_n[1] bl2[1] bl2_n[1] wl1[0] wl2[0] wl1[1] wl2[1]
+ nwell DP8TArray_2X1
X$2 \$1 vss vdd bl1[0] bl1_n[0] bl2[0] bl2_n[0] wl1[0] wl2[0] wl1[1] wl2[1]
+ nwell DP8TArray_2X1
.ENDS DP8TArray_2X2

.SUBCKT DP8TArray_2X1 \$1 vss vdd bl1[0] bl1_n[0] bl2[0] bl2_n[0] wl1[0] wl2[0]
+ wl1[1] wl2[1] \$I9
X$1 bl1[0] vss wl1[1] bl2[0] wl2[1] vdd bl1_n[0] bl2_n[0] \$1 \$I9 DP8TCell
X$2 bl1[0] vss wl1[0] bl2[0] wl2[0] vdd bl1_n[0] bl2_n[0] \$1 \$I9 DP8TCell
.ENDS DP8TArray_2X1

.SUBCKT DP8TCell bl1 vss wl1 bl2 wl2 vdd bl1_n bl2_n \$12 \$13
M$1 bl1 wl1 \$2 \$12 sg13_lv_nmos L=0.13u W=0.2u AS=0.068p AD=0.102p PS=1.08u
+ PD=0.926666666667u
M$2 vss \$6 \$2 \$12 sg13_lv_nmos L=0.13u W=0.2u AS=0.068p AD=0.102p PS=1.08u
+ PD=0.926666666667u
M$3 \$2 wl2 bl2 \$12 sg13_lv_nmos L=0.13u W=0.2u AS=0.102p AD=0.068p
+ PS=0.926666666667u PD=1.08u
M$4 bl1_n wl1 \$6 \$12 sg13_lv_nmos L=0.13u W=0.2u AS=0.068p AD=0.102p PS=1.08u
+ PD=0.926666666667u
M$5 \$6 \$2 vss \$12 sg13_lv_nmos L=0.13u W=0.2u AS=0.102p AD=0.068p
+ PS=0.926666666667u PD=1.08u
M$6 \$6 wl2 bl2_n \$12 sg13_lv_nmos L=0.13u W=0.2u AS=0.102p AD=0.068p
+ PS=0.926666666667u PD=1.08u
M$7 vdd \$6 \$2 \$13 sg13_lv_pmos L=0.13u W=0.15u AS=0.0705p AD=0.09225p
+ PS=1.14u PD=1.43u
M$8 \$6 \$2 vdd \$13 sg13_lv_pmos L=0.13u W=0.15u AS=0.09225p AD=0.0705p
+ PS=1.43u PD=1.14u
.ENDS DP8TCell
