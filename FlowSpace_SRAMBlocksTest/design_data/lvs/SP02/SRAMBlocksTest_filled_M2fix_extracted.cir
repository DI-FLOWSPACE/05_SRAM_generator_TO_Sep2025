* Extracted by KLayout with SG13G2 LVS runset on : 17/10/2025 11:15

.SUBCKT SP02 vss in_srout vdd_block vdd_periph out_srout out_latch clk in_shift
+ out_srin out_l2s out_shift in_latch in_srin
X$2 vss out_l2s out_shift out_srout vdd_periph out_srin clk out_latch in_latch
+ in_shift in_srin in_srout vdd_block SP6TBlock_256x16_332A2WE_Test
.ENDS SP02

.SUBCKT SP6TBlock_256x16_332A2WE_Test vss out_l2s out_shift out_srout
+ vdd_periph out_srin clk out_latch in_latch in_shift in_srin in_srout vdd_block
X$1 vss clk \$44 \$14 \$45 \$15 \$46 \$16 \$47 \$17 \$61 \$18 \$48 \$19 \$49
+ \$20 \$50 \$21 \$51 \$52 \$22 \$53 \$23 \$54 \$24 \$55 \$25 \$56 \$26 \$57
+ \$27 \$58 \$28 \$59 \$29 \$60 \$42 \$43 vdd_block \$37 \$38 \$39 \$40 \$41
+ \$36 SP6TBlock_256x16_332A2WE
X$2 vss in_shift \$32 vdd_periph \$33 in_latch \$44 \$45 \$46 \$47 \$61 \$48
+ \$49 \$50 \$51 SP6TTimingIn_9SL
X$3 vss out_shift out_l2s \$6 vdd_periph \$5 out_latch \$14 \$15 \$16 \$17 \$18
+ \$19 \$20 \$21 SP6TTimingOut_8SL
X$4 vss in_shift \$33 vdd_periph in_srout in_latch \$52 \$53 \$54 \$55 \$56
+ \$57 \$58 \$59 \$60 SP6TTimingIn_9SL
X$5 vss out_shift out_l2s out_srout vdd_periph \$6 out_latch \$22 \$23 \$24
+ \$25 \$26 \$27 \$28 \$29 SP6TTimingOut_8SL
X$6 vss in_shift in_srin vdd_periph \$32 in_latch \$36 \$37 \$38 \$39 \$40 \$41
+ \$42 \$43 SP6TTimingIn_8SF
X$10 vss vdd_periph out_shift out_l2s in_latch out_latch clk out_srin \$5
+ SP6TTimingOut_2SL
.ENDS SP6TBlock_256x16_332A2WE_Test

.SUBCKT SP6TTimingOut_2SL vss vdd sr_shift l2s o[0] o[1] sr_latch sr_in sr_out
X$1 vss \$11 \$10 sr_shift vdd dff_x1
X$2 vss o[0] \$12 sr_latch vdd dff_x1
X$3 vdd vss l2s sr_in \$12 \$11 mux2_x1
X$4 vdd vss l2s \$10 \$15 \$14 mux2_x1
X$5 vss \$14 sr_out sr_shift vdd dff_x1
X$6 vss o[1] \$15 sr_latch vdd dff_x1
.ENDS SP6TTimingOut_2SL

.SUBCKT SP6TTimingOut_8SL vss sr_shift l2s sr_out vdd sr_in sr_latch o[0] o[1]
+ o[2] o[3] o[4] o[5] o[6] o[7]
X$1 vss \$9 \$10 sr_shift vdd dff_x1
X$2 vss o[0] \$25 sr_latch vdd dff_x1
X$3 vdd vss l2s sr_in \$25 \$9 mux2_x1
X$4 vdd vss l2s \$10 \$5 \$11 mux2_x1
X$5 vss \$11 \$12 sr_shift vdd dff_x1
X$6 vss o[1] \$5 sr_latch vdd dff_x1
X$7 vss \$13 \$14 sr_shift vdd dff_x1
X$8 vss o[2] \$26 sr_latch vdd dff_x1
X$9 vdd vss l2s \$12 \$26 \$13 mux2_x1
X$10 vdd vss l2s \$14 \$6 \$15 mux2_x1
X$11 vss \$15 \$16 sr_shift vdd dff_x1
X$12 vss o[3] \$6 sr_latch vdd dff_x1
X$13 vss \$17 \$18 sr_shift vdd dff_x1
X$14 vss o[4] \$28 sr_latch vdd dff_x1
X$15 vdd vss l2s \$16 \$28 \$17 mux2_x1
X$16 vdd vss l2s \$18 \$7 \$19 mux2_x1
X$17 vss \$19 \$20 sr_shift vdd dff_x1
X$18 vss o[5] \$7 sr_latch vdd dff_x1
X$19 vss \$21 \$22 sr_shift vdd dff_x1
X$20 vss o[6] \$29 sr_latch vdd dff_x1
X$21 vdd vss l2s \$20 \$29 \$21 mux2_x1
X$22 vdd vss l2s \$22 \$8 \$23 mux2_x1
X$23 vss \$23 sr_out sr_shift vdd dff_x1
X$24 vss o[7] \$8 sr_latch vdd dff_x1
.ENDS SP6TTimingOut_8SL

.SUBCKT SP6TTimingIn_9SL vss sr_shift sr_in vdd sr_out sr_latch i[0] i[1] i[2]
+ i[3] i[4] i[5] i[6] i[7] i[8]
X$1 vss sr_in \$5 sr_shift vdd dff_x1
X$2 vss \$5 i[0] sr_latch vdd dff_x1
X$3 vss \$5 \$6 sr_shift vdd dff_x1
X$4 vss \$6 i[1] sr_latch vdd dff_x1
X$5 vss \$6 \$7 sr_shift vdd dff_x1
X$6 vss \$7 i[2] sr_latch vdd dff_x1
X$7 vss \$7 \$8 sr_shift vdd dff_x1
X$8 vss \$8 i[3] sr_latch vdd dff_x1
X$9 vss \$8 \$9 sr_shift vdd dff_x1
X$10 vss \$9 i[4] sr_latch vdd dff_x1
X$11 vss \$9 \$10 sr_shift vdd dff_x1
X$12 vss \$10 i[5] sr_latch vdd dff_x1
X$13 vss \$10 \$11 sr_shift vdd dff_x1
X$14 vss \$11 i[6] sr_latch vdd dff_x1
X$15 vss \$11 \$12 sr_shift vdd dff_x1
X$16 vss \$12 i[7] sr_latch vdd dff_x1
X$17 vss \$12 sr_out sr_shift vdd dff_x1
X$18 vss sr_out i[8] sr_latch vdd dff_x1
.ENDS SP6TTimingIn_9SL

.SUBCKT SP6TTimingIn_8SF vss sr_shift sr_in vdd sr_out sr_latch i[7] i[6] i[5]
+ i[4] i[3] i[2] i[1] i[0]
X$1 vss sr_in \$5 sr_shift vdd dff_x1
X$2 vss \$5 i[7] sr_latch vdd dff_x1
X$3 vss \$5 \$6 sr_shift vdd dff_x1
X$4 vss \$6 i[6] sr_latch vdd dff_x1
X$5 vss \$6 \$7 sr_shift vdd dff_x1
X$6 vss \$7 i[5] sr_latch vdd dff_x1
X$7 vss \$7 \$8 sr_shift vdd dff_x1
X$8 vss \$8 i[4] sr_latch vdd dff_x1
X$9 vss \$8 \$9 sr_shift vdd dff_x1
X$10 vss \$9 i[3] sr_latch vdd dff_x1
X$11 vss \$9 \$10 sr_shift vdd dff_x1
X$12 vss \$10 i[2] sr_latch vdd dff_x1
X$13 vss \$10 \$11 sr_shift vdd dff_x1
X$14 vss \$11 i[1] sr_latch vdd dff_x1
X$15 vss \$11 sr_out sr_shift vdd dff_x1
X$16 vss sr_out i[0] sr_latch vdd dff_x1
.ENDS SP6TTimingIn_8SF

.SUBCKT SP6TBlock_256x16_332A2WE vss clk d[0] q[0] d[1] q[1] d[2] q[2] d[3]
+ q[3] d[4] q[4] d[5] q[5] d[6] q[6] d[7] q[7] we[0] d[8] q[8] d[9] q[9] d[10]
+ q[10] d[11] q[11] d[12] q[12] d[13] q[13] d[14] q[14] d[15] q[15] we[1] a[1]
+ a[0] vdd a[6] a[5] a[4] a[3] a[2] a[7]
X$1 vss clk \$38 \$37 vdd \$41 a[0] \$48 \$49 a[1] \$47 \$46 a[2] a[3] a[4]
+ a[5] a[6] a[7] SP6TRowPeriphery_3_3_2
X$2 vss d[0] q[0] d[1] q[1] d[2] q[2] d[3] q[3] d[4] q[4] d[5] q[5] d[6] q[6]
+ d[7] q[7] we[0] d[8] q[8] d[9] q[9] d[10] q[10] d[11] q[11] \$38 \$37 d[12]
+ q[12] d[13] q[13] d[14] q[14] d[15] q[15] we[1] vdd \$48 \$49 \$46 \$47
+ SP6TColumnBlock_64R16B4M2W
.ENDS SP6TBlock_256x16_332A2WE

.SUBCKT mux2_x1 vdd vss cmd i0 i1 q
M$1 \$1 cmd vss vss sg13_lv_nmos L=0.13u W=0.78u AS=0.2652p AD=0.1482p PS=2.24u
+ PD=1.16u
M$2 vss i0 \$9 vss sg13_lv_nmos L=0.13u W=0.78u AS=0.1482p AD=0.1482p PS=1.16u
+ PD=1.16u
M$3 \$9 \$1 \$6 vss sg13_lv_nmos L=0.13u W=0.78u AS=0.1482p AD=0.195p PS=1.16u
+ PD=1.28u
M$4 \$6 cmd \$10 vss sg13_lv_nmos L=0.13u W=0.78u AS=0.195p AD=0.1482p PS=1.28u
+ PD=1.16u
M$5 \$10 i1 vss vss sg13_lv_nmos L=0.13u W=0.78u AS=0.1482p AD=0.2092p PS=1.16u
+ PD=1.48u
M$6 vss \$6 q vss sg13_lv_nmos L=0.13u W=1.07u AS=0.2092p AD=0.3638p PS=1.48u
+ PD=2.82u
M$7 \$1 cmd vdd vdd sg13_lv_pmos L=0.13u W=0.78u AS=0.2652p AD=0.1482p PS=2.24u
+ PD=1.16u
M$8 vdd i0 \$11 vdd sg13_lv_pmos L=0.13u W=0.78u AS=0.1482p AD=0.1482p PS=1.16u
+ PD=1.16u
M$9 \$11 cmd \$6 vdd sg13_lv_pmos L=0.13u W=0.78u AS=0.1482p AD=0.195p PS=1.16u
+ PD=1.28u
M$10 \$6 \$1 \$12 vdd sg13_lv_pmos L=0.13u W=0.78u AS=0.195p AD=0.1482p
+ PS=1.28u PD=1.16u
M$11 vdd i1 \$12 vdd sg13_lv_pmos L=0.13u W=0.78u AS=0.2075p AD=0.1482p
+ PS=1.47u PD=1.16u
M$12 vdd \$6 q vdd sg13_lv_pmos L=0.13u W=1.06u AS=0.2075p AD=0.3604p PS=1.47u
+ PD=2.8u
.ENDS mux2_x1

.SUBCKT SP6TColumnBlock_64R16B4M2W vss d[0] q[0] d[1] q[1] d[2] q[2] d[3] q[3]
+ d[4] q[4] d[5] q[5] d[6] q[6] d[7] q[7] we[0] d[8] q[8] d[9] q[9] d[10] q[10]
+ d[11] q[11] clk we_en d[12] q[12] d[13] q[13] d[14] q[14] d[15] q[15] we[1]
+ vdd mux[0] mux[1] mux[3] mux[2]
X$1 vss d[8] q[8] d[9] q[9] d[10] q[10] d[11] q[11] d[12] q[12] d[13] q[13]
+ d[14] q[14] d[15] q[15] we[1] clk we_en \$237 \$304 \$302 \$301 \$299 \$298
+ \$296 \$295 \$293 \$292 \$290 \$289 \$286 \$285 \$282 \$281 \$278 \$277 \$274
+ \$273 \$270 \$269 \$266 \$265 \$262 \$261 \$258 \$257 \$254 \$253 \$250 \$249
+ vdd mux[0] \$246 \$245 \$242 \$241 \$284 \$280 \$272 \$268 \$260 \$256 \$248
+ \$244 \$235 \$231 \$223 \$219 \$211 \$207 \$199 \$195 \$187 \$183 \$175 \$171
+ \$162 \$158 \$150 \$146 \$138 \$134 \$126 \$122 mux[3] mux[2] mux[1]
+ SP6TColumn_64R8B4M
X$2 vss d[0] q[0] d[1] q[1] d[2] q[2] d[3] q[3] d[4] q[4] d[5] q[5] d[6] q[6]
+ d[7] q[7] we[0] clk we_en \$164 \$163 \$160 \$159 \$156 \$155 \$152 \$151
+ \$148 \$147 \$144 \$143 \$140 \$139 \$136 \$135 \$132 \$131 \$128 \$127 \$124
+ \$123 \$120 \$119 \$116 \$115 \$112 \$234 \$233 \$232 \$229 \$228 vdd mux[0]
+ \$225 \$224 \$221 \$220 \$217 \$216 \$213 \$212 \$209 \$208 \$205 \$204 \$201
+ \$200 \$197 \$196 \$193 \$192 \$189 \$188 \$185 \$184 \$181 \$180 \$177 \$176
+ \$173 \$172 \$169 \$168 \$165 \$240 mux[3] mux[2] mux[1] SP6TColumn_64R8B4M
.ENDS SP6TColumnBlock_64R16B4M2W

.SUBCKT SP6TRowPeriphery_3_3_2 vss clk columnclk we_en vdd precharge_n a[0]
+ mux[0] mux[1] a[1] mux[2] mux[3] a[2] a[3] a[4] a[5] a[6] a[7]
X$1 vss vdd clk \$7 wl_en precharge_n columnclk we_en SP6TClockGenerator_8S1R
X$2 vss vdd a[2] a[3] a[4] \$7 a[5] a[6] a[7] SP6TRowDecoder_3_3B
X$3 vss vdd a[0] a[1] mux[0] mux[1] mux[2] mux[3] \$7 SP6TLatchedDecoder_2A2R
.ENDS SP6TRowPeriphery_3_3_2

.SUBCKT SP6TColumn_64R8B4M vss d[0] q[0] d[1] q[1] d[2] q[2] d[3] q[3] d[4]
+ q[4] d[5] q[5] d[6] q[6] d[7] q[7] we clk we_en bl[0] bl_n[0] bl_n[1] bl[1]
+ bl[2] bl_n[2] bl_n[3] bl[3] bl[4] bl_n[4] bl_n[5] bl[5] bl[6] bl_n[6] bl_n[7]
+ bl[7] bl[8] bl_n[8] bl_n[9] bl[9] bl[10] bl_n[10] bl_n[11] bl[11] bl[12]
+ bl_n[12] bl_n[13] bl[13] bl[14] bl_n[14] bl_n[15] bl[15] vdd mux[0] bl[16]
+ bl_n[16] bl_n[17] bl[17] bl[18] bl_n[18] bl_n[19] bl[19] bl[20] bl_n[20]
+ bl_n[21] bl[21] bl[22] bl_n[22] bl_n[23] bl[23] bl[24] bl_n[24] bl_n[25]
+ bl[25] bl[26] bl_n[26] bl_n[27] bl[27] bl[28] bl_n[28] bl_n[29] bl[29] bl[30]
+ bl_n[30] bl_n[31] bl[31] mux[3] mux[2] mux[1]
X$1 vss we d[0] d[1] vdd d[2] d[3] d[4] d[5] d[6] clk d[7] we_en q[0] q[1] q[2]
+ q[3] q[4] q[5] q[6] q[7] bl[0] bl_n[0] bl_n[1] bl[1] bl[2] bl_n[2] bl_n[3]
+ bl[3] bl[4] bl_n[4] bl_n[5] bl[5] bl[6] bl_n[6] bl_n[7] bl[7] bl[8] bl_n[8]
+ bl_n[9] bl[9] bl[10] bl_n[10] bl_n[11] bl[11] bl[12] bl_n[12] bl_n[13] bl[13]
+ bl[14] bl_n[14] bl_n[15] bl[15] mux[0] bl[16] bl_n[16] bl_n[17] bl[17] bl[18]
+ bl_n[18] bl_n[19] bl[19] bl[20] bl_n[20] bl_n[21] bl[21] bl[22] bl_n[22]
+ bl_n[23] bl[23] bl[24] bl_n[24] bl_n[25] bl[25] bl[26] bl_n[26] bl_n[27]
+ bl[27] bl[28] bl_n[28] bl_n[29] bl[29] bl[30] bl_n[30] bl_n[31] bl[31] mux[3]
+ mux[1] mux[2] SP6TColumnPeriphery_8B4M
.ENDS SP6TColumn_64R8B4M

.SUBCKT SP6TClockGenerator_8S1R vss vdd clk decodeclk wl_en precharge_n
+ columnclk we_en
X$1 vdd vss \$7 wl_en buf_x1
X$2 vdd vss clk decodeclk buf_x1
X$3 vss vdd precharge_n \$10 inv_x1
X$4 vdd vss clk columnclk buf_x1
X$5 vss vdd \$7 \$10 clk SP6TNonOverlapClock_8S1R
X$6 vdd vss \$7 we_en buf_x1
.ENDS SP6TClockGenerator_8S1R

.SUBCKT SP6TLatchedDecoder_2A2R vss vdd a[0] a[1] line[0] line[1] line[2]
+ line[3] clk
X$1 vss a[0] \$11 clk vdd SP6TDec_dff_x1
X$2 vss a[1] \$12 clk vdd SP6TDec_dff_x1
X$3 vss vdd \$13 \$11 SP6TDec_inv_x1
X$4 vss vdd \$13 \$16 \$14 SP6TDec_nand2_x0
X$5 vss vdd line[0] \$16 SP6TDec_inv_x2
X$6 vss vdd \$11 \$17 \$14 SP6TDec_nand2_x0
X$7 vss vdd line[1] \$17 SP6TDec_inv_x2
X$8 vss vdd \$13 \$18 \$12 SP6TDec_nand2_x0
X$9 vss vdd \$14 \$12 SP6TDec_inv_x1
X$10 vss vdd line[2] \$18 SP6TDec_inv_x2
X$11 vss vdd \$11 \$19 \$12 SP6TDec_nand2_x0
X$12 vss vdd line[3] \$19 SP6TDec_inv_x2
.ENDS SP6TLatchedDecoder_2A2R

.SUBCKT SP6TRowDecoder_3_3B vss vdd a[0] a[1] a[2] clk a[3] a[4] a[5]
X$1 vss vdd \$7 \$35 \$8 \$26 \$98 \$27 \$43 \$162 \$34 \$205 \$52 \$44 \$252
+ \$325 \$383 \$448 clk a[0] a[1] a[2] a[3] a[4] a[5] SP6TRowPredecoders_3_3B
.ENDS SP6TRowDecoder_3_3B

.SUBCKT SP6TColumnPeriphery_8B4M vss we d[0] d[1] vdd d[2] d[3] d[4] d[5] d[6]
+ clk d[7] we_en q[0] q[1] q[2] q[3] q[4] q[5] q[6] q[7] bl[0] bl_n[0] bl_n[1]
+ bl[1] bl[2] bl_n[2] bl_n[3] bl[3] bl[4] bl_n[4] bl_n[5] bl[5] bl[6] bl_n[6]
+ bl_n[7] bl[7] bl[8] bl_n[8] bl_n[9] bl[9] bl[10] bl_n[10] bl_n[11] bl[11]
+ bl[12] bl_n[12] bl_n[13] bl[13] bl[14] bl_n[14] bl_n[15] bl[15] mux[0] bl[16]
+ bl_n[16] bl_n[17] bl[17] bl[18] bl_n[18] bl_n[19] bl[19] bl[20] bl_n[20]
+ bl_n[21] bl[21] bl[22] bl_n[22] bl_n[23] bl[23] bl[24] bl_n[24] bl_n[25]
+ bl[25] bl[26] bl_n[26] bl_n[27] bl[27] bl[28] bl_n[28] bl_n[29] bl[29] bl[30]
+ bl_n[30] bl_n[31] bl[31] mux[3] mux[1] mux[2]
X$1 \$103 bl[4] bl_n[4] \$100 bl_n[5] bl[5] bl[6] bl_n[6] bl_n[7] bl[7] mux[0]
+ vss mux[1] mux[2] mux[3] SP6TColMux_4C
X$2 \$93 bl[0] bl_n[0] \$95 bl_n[1] bl[1] bl[2] bl_n[2] bl_n[3] bl[3] mux[0]
+ vss mux[1] mux[2] mux[3] SP6TColMux_4C
X$8 \$107 bl[8] bl_n[8] \$106 bl_n[9] bl[9] bl[10] bl_n[10] bl_n[11] bl[11]
+ mux[0] vss mux[1] mux[2] mux[3] SP6TColMux_4C
X$13 \$104 bl[12] bl_n[12] \$105 bl_n[13] bl[13] bl[14] bl_n[14] bl_n[15]
+ bl[15] mux[0] vss mux[1] mux[2] mux[3] SP6TColMux_4C
X$18 \$101 bl[16] bl_n[16] \$102 bl_n[17] bl[17] bl[18] bl_n[18] bl_n[19]
+ bl[19] mux[0] vss mux[1] mux[2] mux[3] SP6TColMux_4C
X$23 \$99 bl[20] bl_n[20] \$98 bl_n[21] bl[21] bl[22] bl_n[22] bl_n[23] bl[23]
+ mux[0] vss mux[1] mux[2] mux[3] SP6TColMux_4C
X$28 \$96 bl[24] bl_n[24] \$97 bl_n[25] bl[25] bl[26] bl_n[26] bl_n[27] bl[27]
+ mux[0] vss mux[1] mux[2] mux[3] SP6TColMux_4C
X$33 \$94 bl[28] bl_n[28] \$92 bl_n[29] bl[29] bl[30] bl_n[30] bl_n[31] bl[31]
+ mux[0] vss mux[1] mux[2] mux[3] SP6TColMux_4C
X$41 \$93 vss \$95 vdd q[0] d[0] \$23 \$15 SP6TReadWrite_4M
X$42 \$103 vss \$100 vdd q[1] d[1] \$23 \$15 SP6TReadWrite_4M
X$43 \$107 vss \$106 vdd q[2] d[2] \$23 \$15 SP6TReadWrite_4M
X$44 \$104 vss \$105 vdd q[3] d[3] \$23 \$15 SP6TReadWrite_4M
X$45 \$101 vss \$102 vdd q[4] d[4] \$23 \$15 SP6TReadWrite_4M
X$46 \$99 vss \$98 vdd q[5] d[5] \$23 \$15 SP6TReadWrite_4M
X$47 clk we we_en \$15 vss vdd \$23 SP6TClockWE
X$48 \$96 vss \$97 vdd q[6] d[6] \$23 \$15 SP6TReadWrite_4M
X$49 \$94 vss \$92 vdd q[7] d[7] \$23 \$15 SP6TReadWrite_4M
.ENDS SP6TColumnPeriphery_8B4M

.SUBCKT SP6TNonOverlapClock_8S1R vss vdd firststage[7] secondstage[7] clk
X$1 vss vdd secondstage[8] secondstage[7] inv_x0
X$2 vss vdd secondstage[7] secondstage[6] inv_x0
X$3 vss vdd secondstage[6] secondstage[5] inv_x0
X$4 vss vdd secondstage[5] secondstage[4] inv_x0
X$5 vss vdd secondstage[4] secondstage[3] inv_x0
X$6 vss vdd secondstage[3] secondstage[2] inv_x0
X$7 vss vdd secondstage[2] secondstage[1] inv_x0
X$8 vss vdd secondstage[1] secondstage[0] inv_x0
X$9 vss vdd \$23 secondstage[0] firststage[8] nand2_x0
X$10 vss vdd \$23 clk inv_x0
X$11 vss vdd clk firststage[0] secondstage[8] nand2_x0
X$12 vss vdd firststage[1] firststage[0] inv_x0
X$13 vss vdd firststage[2] firststage[1] inv_x0
X$14 vss vdd firststage[3] firststage[2] inv_x0
X$15 vss vdd firststage[4] firststage[3] inv_x0
X$16 vss vdd firststage[5] firststage[4] inv_x0
X$17 vss vdd firststage[6] firststage[5] inv_x0
X$18 vss vdd firststage[7] firststage[6] inv_x0
X$19 vss vdd firststage[8] firststage[7] inv_x0
.ENDS SP6TNonOverlapClock_8S1R

.SUBCKT inv_x1 vss vdd nq i
M$1 vss i nq vss sg13_lv_nmos L=0.13u W=1.46u AS=0.4964p AD=0.4964p PS=3.6u
+ PD=3.6u
M$2 vdd i nq vdd sg13_lv_pmos L=0.13u W=1.45u AS=0.493p AD=0.493p PS=3.58u
+ PD=3.58u
.ENDS inv_x1

.SUBCKT buf_x1 vdd vss i q
M$1 \$1 i vss vss sg13_lv_nmos L=0.13u W=0.78u AS=0.2652p AD=0.2092p PS=2.24u
+ PD=1.48u
M$2 vss \$1 q vss sg13_lv_nmos L=0.13u W=1.07u AS=0.2092p AD=0.3638p PS=1.48u
+ PD=2.82u
M$3 vdd i \$1 vdd sg13_lv_pmos L=0.13u W=0.78u AS=0.2075p AD=0.2652p PS=1.47u
+ PD=2.24u
M$4 vdd \$1 q vdd sg13_lv_pmos L=0.13u W=1.06u AS=0.2075p AD=0.3604p PS=1.47u
+ PD=2.8u
.ENDS buf_x1

.SUBCKT SP6TDec_inv_x2 vss vdd nq i
M$1 vss i nq vss sg13_lv_nmos L=0.13u W=5.6u AS=1.484p AD=1.484p PS=9.46u
+ PD=9.46u
M$3 vdd i nq vdd sg13_lv_pmos L=0.13u W=8.8u AS=2.332p AD=2.332p PS=14.26u
+ PD=14.26u
.ENDS SP6TDec_inv_x2

.SUBCKT SP6TDec_nand2_x0 vss vdd i0 nq i1
M$1 vss i0 \$6 vss sg13_lv_nmos L=0.13u W=0.78u AS=0.2652p AD=0.1482p PS=2.24u
+ PD=1.16u
M$2 \$6 i1 nq vss sg13_lv_nmos L=0.13u W=0.78u AS=0.1482p AD=0.312p PS=1.16u
+ PD=2.36u
M$3 vdd i0 nq vdd sg13_lv_pmos L=0.13u W=1.2u AS=0.408p AD=0.228p PS=3.08u
+ PD=1.58u
M$4 nq i1 vdd vdd sg13_lv_pmos L=0.13u W=1.2u AS=0.228p AD=0.48p PS=1.58u
+ PD=3.2u
.ENDS SP6TDec_nand2_x0

.SUBCKT SP6TRowPredecoders_3_3B vss vdd pd[0][0] page[0] pd[0][1] pd[0][2]
+ page[1] pd[0][3] pd[0][4] page[2] pd[0][5] page[3] pd[0][6] pd[0][7] page[4]
+ page[5] page[6] page[7] clk a[0] a[1] a[2] a[3] a[4] a[5]
X$1 vss a[0] \$25 clk vdd SP6TDec_dff_x1
X$2 vss vdd \$19 \$25 SP6TDec_inv_x1
X$3 vdd vss \$19 \$20 \$21 pd[0][0] SP6TDec_and3_x1
X$4 vdd vss \$22 \$23 \$24 page[0] SP6TDec_and3_x1
X$5 vdd vss \$25 \$20 \$21 pd[0][1] SP6TDec_and3_x1
X$6 vss a[1] \$26 clk vdd SP6TDec_dff_x1
X$7 vdd vss \$19 \$26 \$21 pd[0][2] SP6TDec_and3_x1
X$8 vss vdd \$20 \$26 SP6TDec_inv_x1
X$9 vdd vss \$27 \$23 \$24 page[1] SP6TDec_and3_x1
X$10 vdd vss \$25 \$26 \$21 pd[0][3] SP6TDec_and3_x1
X$11 vss a[2] \$28 clk vdd SP6TDec_dff_x1
X$12 vdd vss \$19 \$20 \$28 pd[0][4] SP6TDec_and3_x1
X$13 vss vdd \$21 \$28 SP6TDec_inv_x1
X$14 vdd vss \$22 \$29 \$24 page[2] SP6TDec_and3_x1
X$15 vdd vss \$25 \$20 \$28 pd[0][5] SP6TDec_and3_x1
X$16 vss a[3] \$27 clk vdd SP6TDec_dff_x1
X$17 vdd vss \$27 \$29 \$24 page[3] SP6TDec_and3_x1
X$18 vss vdd \$22 \$27 SP6TDec_inv_x1
X$19 vdd vss \$19 \$26 \$28 pd[0][6] SP6TDec_and3_x1
X$20 vdd vss \$25 \$26 \$28 pd[0][7] SP6TDec_and3_x1
X$21 vss a[4] \$29 clk vdd SP6TDec_dff_x1
X$22 vdd vss \$22 \$23 \$30 page[4] SP6TDec_and3_x1
X$23 vss vdd \$23 \$29 SP6TDec_inv_x1
X$26 vss a[5] \$30 clk vdd SP6TDec_dff_x1
X$27 vdd vss \$27 \$23 \$30 page[5] SP6TDec_and3_x1
X$28 vss vdd \$24 \$30 SP6TDec_inv_x1
X$32 vdd vss \$22 \$29 \$30 page[6] SP6TDec_and3_x1
X$38 vdd vss \$27 \$29 \$30 page[7] SP6TDec_and3_x1
.ENDS SP6TRowPredecoders_3_3B

.SUBCKT SP6TColMux_4C muxbl bl[0] bl_n[0] muxbl_n bl_n[1] bl[1] bl[2] bl_n[2]
+ bl_n[3] bl[3] mux[0] vss mux[1] mux[2] mux[3]
M$1 bl[3] mux[3] muxbl vss sg13_lv_nmos L=0.13u W=3.5u AS=1.19p AD=1.19p
+ PS=7.68u PD=7.68u
M$2 bl_n[2] mux[2] muxbl_n vss sg13_lv_nmos L=0.13u W=3.5u AS=1.19p AD=0.665p
+ PS=7.68u PD=3.88u
M$3 muxbl_n mux[3] bl_n[3] vss sg13_lv_nmos L=0.13u W=3.5u AS=0.665p AD=1.19p
+ PS=3.88u PD=7.68u
M$4 bl[1] mux[1] muxbl vss sg13_lv_nmos L=0.13u W=3.5u AS=1.19p AD=0.665p
+ PS=7.68u PD=3.88u
M$5 muxbl mux[2] bl[2] vss sg13_lv_nmos L=0.13u W=3.5u AS=0.665p AD=1.19p
+ PS=3.88u PD=7.68u
M$6 bl_n[0] mux[0] muxbl_n vss sg13_lv_nmos L=0.13u W=3.5u AS=1.19p AD=0.665p
+ PS=7.68u PD=3.88u
M$7 muxbl_n mux[1] bl_n[1] vss sg13_lv_nmos L=0.13u W=3.5u AS=0.665p AD=1.19p
+ PS=3.88u PD=7.68u
M$8 muxbl mux[0] bl[0] vss sg13_lv_nmos L=0.13u W=3.5u AS=1.19p AD=1.19p
+ PS=7.68u PD=7.68u
.ENDS SP6TColMux_4C

.SUBCKT SP6TReadWrite_4M bl vss bl_n vdd q d clk we_n
X$1 q vdd vss bl_n bl nsnrlatch_x1
X$2 vss vdd \$5 \$16 we_n nor2_x0
X$3 vss vdd \$16 \$11 inv_x0
X$4 vss d \$11 clk vdd dff_x1
X$5 vss vdd \$3 \$11 we_n nor2_x0
M$1 bl \$3 vss vss sg13_lv_nmos L=0.13u W=1.9u AS=0.5074p AD=0.361p PS=4.48u
+ PD=2.28u
M$2 vss \$5 bl_n vss sg13_lv_nmos L=0.13u W=1.9u AS=0.361p AD=0.5074p PS=2.28u
+ PD=4.48u
.ENDS SP6TReadWrite_4M

.SUBCKT SP6TClockWE clkup we we_en we_n vss vdd clkdown
X$1 vdd vss clkup clkdown buf_x2
X$2 vss we \$9 clkdown vdd dff_x1
X$3 vss vdd \$9 we_n we_en nand2_x0
.ENDS SP6TClockWE

.SUBCKT SP6TDec_and3_x1 vdd vss i0 i1 i2 q
M$1 \$1 i0 \$9 vss sg13_lv_nmos L=0.13u W=0.78u AS=0.2652p AD=0.1482p PS=2.24u
+ PD=1.16u
M$2 \$9 i1 \$8 vss sg13_lv_nmos L=0.13u W=0.78u AS=0.1482p AD=0.1482p PS=1.16u
+ PD=1.16u
M$3 \$8 i2 vss vss sg13_lv_nmos L=0.13u W=0.78u AS=0.1482p AD=0.5033p PS=1.16u
+ PD=3.21u
M$4 vss \$1 q vss sg13_lv_nmos L=0.13u W=2.8u AS=0.5033p AD=1.036p PS=3.21u
+ PD=6.34u
M$5 \$1 i0 vdd vdd sg13_lv_pmos L=0.13u W=1.2u AS=0.408p AD=0.228p PS=3.08u
+ PD=1.58u
M$6 vdd i1 \$1 vdd sg13_lv_pmos L=0.13u W=1.2u AS=0.228p AD=0.228p PS=1.58u
+ PD=1.58u
M$7 vdd i2 \$1 vdd sg13_lv_pmos L=0.13u W=1.2u AS=0.79p AD=0.228p PS=4.81u
+ PD=1.58u
M$8 vdd \$1 q vdd sg13_lv_pmos L=0.13u W=4.4u AS=0.79p AD=1.628p PS=4.81u
+ PD=9.54u
.ENDS SP6TDec_and3_x1

.SUBCKT SP6TDec_inv_x1 vss vdd nq i
M$1 vss i nq vss sg13_lv_nmos L=0.13u W=2.8u AS=0.952p AD=0.952p PS=6.28u
+ PD=6.28u
M$2 vdd i nq vdd sg13_lv_pmos L=0.13u W=4.4u AS=1.496p AD=1.496p PS=9.48u
+ PD=9.48u
.ENDS SP6TDec_inv_x1

.SUBCKT SP6TDec_dff_x1 vss i q clk vdd
M$1 \$4 i vss vss sg13_lv_nmos L=0.13u W=0.78u AS=0.2652p AD=0.1482p PS=2.24u
+ PD=1.16u
M$2 vss \$4 \$11 vss sg13_lv_nmos L=0.13u W=0.78u AS=0.1482p AD=0.1482p
+ PS=1.16u PD=1.16u
M$3 \$11 \$2 \$6 vss sg13_lv_nmos L=0.13u W=0.78u AS=0.1482p AD=0.1482p
+ PS=1.16u PD=1.16u
M$4 \$6 \$3 \$12 vss sg13_lv_nmos L=0.13u W=0.78u AS=0.1482p AD=0.1482p
+ PS=1.16u PD=1.16u
M$5 \$12 \$7 vss vss sg13_lv_nmos L=0.13u W=0.78u AS=0.1482p AD=0.1638p
+ PS=1.16u PD=1.2u
M$6 vss \$6 \$7 vss sg13_lv_nmos L=0.13u W=0.78u AS=0.1638p AD=0.2496p PS=1.2u
+ PD=1.42u
M$7 \$7 \$3 \$8 vss sg13_lv_nmos L=0.13u W=0.78u AS=0.2496p AD=0.1482p PS=1.42u
+ PD=1.16u
M$8 \$8 \$2 \$10 vss sg13_lv_nmos L=0.13u W=0.78u AS=0.1482p AD=0.1482p
+ PS=1.16u PD=1.16u
M$9 \$10 q vss vss sg13_lv_nmos L=0.13u W=0.78u AS=0.1482p AD=0.7217p PS=1.16u
+ PD=2.88u
M$10 vss \$8 q vss sg13_lv_nmos L=0.13u W=2.17u AS=0.7217p AD=0.7378p PS=2.88u
+ PD=5.02u
M$11 \$2 clk vss vss sg13_lv_nmos L=0.13u W=0.78u AS=0.2652p AD=0.1716p
+ PS=2.24u PD=1.22u
M$12 vss \$2 \$3 vss sg13_lv_nmos L=0.13u W=0.78u AS=0.1716p AD=0.2652p
+ PS=1.22u PD=2.24u
M$13 \$2 clk vdd vdd sg13_lv_pmos L=0.13u W=1.2u AS=0.408p AD=0.264p PS=3.08u
+ PD=1.64u
M$14 vdd \$2 \$3 vdd sg13_lv_pmos L=0.13u W=1.2u AS=0.264p AD=0.408p PS=1.64u
+ PD=3.08u
M$15 \$4 i vdd vdd sg13_lv_pmos L=0.13u W=1.2u AS=0.408p AD=0.228p PS=3.08u
+ PD=1.58u
M$16 vdd \$4 \$15 vdd sg13_lv_pmos L=0.13u W=1.2u AS=0.228p AD=0.228p PS=1.58u
+ PD=1.58u
M$17 \$15 \$3 \$6 vdd sg13_lv_pmos L=0.13u W=1.2u AS=0.228p AD=0.228p PS=1.58u
+ PD=1.58u
M$18 \$6 \$2 \$16 vdd sg13_lv_pmos L=0.13u W=1.2u AS=0.228p AD=0.228p PS=1.58u
+ PD=1.58u
M$19 \$16 \$7 vdd vdd sg13_lv_pmos L=0.13u W=1.2u AS=0.228p AD=0.252p PS=1.58u
+ PD=1.62u
M$20 vdd \$6 \$7 vdd sg13_lv_pmos L=0.13u W=1.2u AS=0.252p AD=0.384p PS=1.62u
+ PD=1.84u
M$21 \$7 \$2 \$8 vdd sg13_lv_pmos L=0.13u W=1.2u AS=0.384p AD=0.228p PS=1.84u
+ PD=1.58u
M$22 \$8 \$3 \$17 vdd sg13_lv_pmos L=0.13u W=1.2u AS=0.228p AD=0.228p PS=1.58u
+ PD=1.58u
M$23 vdd q \$17 vdd sg13_lv_pmos L=0.13u W=1.2u AS=1.2484p AD=0.228p PS=4.48u
+ PD=1.58u
M$24 vdd \$8 q vdd sg13_lv_pmos L=0.13u W=3.77u AS=1.2484p AD=1.2818p PS=4.48u
+ PD=8.22u
.ENDS SP6TDec_dff_x1

.SUBCKT nor2_x0 vss vdd nq i0 i1
M$1 vss i0 nq vss sg13_lv_nmos L=0.13u W=0.78u AS=0.2652p AD=0.1482p PS=2.24u
+ PD=1.16u
M$2 nq i1 vss vss sg13_lv_nmos L=0.13u W=0.78u AS=0.1482p AD=0.2808p PS=1.16u
+ PD=2.28u
M$3 vdd i0 \$6 vdd sg13_lv_pmos L=0.13u W=0.78u AS=0.2652p AD=0.1482p PS=2.24u
+ PD=1.16u
M$4 \$6 i1 nq vdd sg13_lv_pmos L=0.13u W=0.78u AS=0.1482p AD=0.2808p PS=1.16u
+ PD=2.28u
.ENDS nor2_x0

.SUBCKT nsnrlatch_x1 q vdd vss nset nrst
M$1 q nset \$8 vss sg13_lv_nmos L=0.13u W=1.31u AS=0.4454p AD=0.2489p PS=3.3u
+ PD=1.69u
M$2 \$8 nq vss vss sg13_lv_nmos L=0.13u W=1.31u AS=0.2489p AD=0.2489p PS=1.69u
+ PD=1.69u
M$3 vss q \$7 vss sg13_lv_nmos L=0.13u W=1.31u AS=0.2489p AD=0.262p PS=1.69u
+ PD=1.71u
M$4 \$7 nrst nq vss sg13_lv_nmos L=0.13u W=1.31u AS=0.262p AD=0.4454p PS=1.71u
+ PD=3.3u
M$5 vdd nset q vdd sg13_lv_pmos L=0.13u W=1.3u AS=0.442p AD=0.247p PS=3.28u
+ PD=1.68u
M$6 q nq vdd vdd sg13_lv_pmos L=0.13u W=1.3u AS=0.247p AD=0.247p PS=1.68u
+ PD=1.68u
M$7 vdd q nq vdd sg13_lv_pmos L=0.13u W=1.3u AS=0.247p AD=0.26p PS=1.68u PD=1.7u
M$8 nq nrst vdd vdd sg13_lv_pmos L=0.13u W=1.3u AS=0.26p AD=0.442p PS=1.7u
+ PD=3.28u
.ENDS nsnrlatch_x1

.SUBCKT dff_x1 vss i q clk vdd
M$1 \$4 i vss vss sg13_lv_nmos L=0.13u W=0.78u AS=0.2652p AD=0.1482p PS=2.24u
+ PD=1.16u
M$2 vss \$4 \$12 vss sg13_lv_nmos L=0.13u W=0.78u AS=0.1482p AD=0.1482p
+ PS=1.16u PD=1.16u
M$3 \$12 \$2 \$6 vss sg13_lv_nmos L=0.13u W=0.78u AS=0.1482p AD=0.1482p
+ PS=1.16u PD=1.16u
M$4 \$6 \$3 \$11 vss sg13_lv_nmos L=0.13u W=0.78u AS=0.1482p AD=0.1482p
+ PS=1.16u PD=1.16u
M$5 \$11 \$7 vss vss sg13_lv_nmos L=0.13u W=0.78u AS=0.1482p AD=0.1482p
+ PS=1.16u PD=1.16u
M$6 vss \$6 \$7 vss sg13_lv_nmos L=0.13u W=0.78u AS=0.1482p AD=0.2028p PS=1.16u
+ PD=1.3u
M$7 \$7 \$3 \$8 vss sg13_lv_nmos L=0.13u W=0.78u AS=0.2028p AD=0.1482p PS=1.3u
+ PD=1.16u
M$8 \$8 \$2 \$10 vss sg13_lv_nmos L=0.13u W=0.78u AS=0.1482p AD=0.1482p
+ PS=1.16u PD=1.16u
M$9 \$10 q vss vss sg13_lv_nmos L=0.13u W=0.78u AS=0.1482p AD=0.2265p PS=1.16u
+ PD=1.38u
M$10 vss \$8 q vss sg13_lv_nmos L=0.13u W=0.83u AS=0.2265p AD=0.2822p PS=1.38u
+ PD=2.34u
M$11 \$2 clk vss vss sg13_lv_nmos L=0.13u W=0.78u AS=0.2652p AD=0.156p PS=2.24u
+ PD=1.18u
M$12 vss \$2 \$3 vss sg13_lv_nmos L=0.13u W=0.78u AS=0.156p AD=0.2652p PS=1.18u
+ PD=2.24u
M$13 \$2 clk vdd vdd sg13_lv_pmos L=0.13u W=0.78u AS=0.2652p AD=0.156p PS=2.24u
+ PD=1.18u
M$14 vdd \$2 \$3 vdd sg13_lv_pmos L=0.13u W=0.78u AS=0.156p AD=0.2652p PS=1.18u
+ PD=2.24u
M$15 \$4 i vdd vdd sg13_lv_pmos L=0.13u W=0.78u AS=0.2652p AD=0.1482p PS=2.24u
+ PD=1.16u
M$16 vdd \$4 \$15 vdd sg13_lv_pmos L=0.13u W=0.78u AS=0.1482p AD=0.1482p
+ PS=1.16u PD=1.16u
M$17 \$15 \$3 \$6 vdd sg13_lv_pmos L=0.13u W=0.78u AS=0.1482p AD=0.1482p
+ PS=1.16u PD=1.16u
M$18 \$6 \$2 \$16 vdd sg13_lv_pmos L=0.13u W=0.78u AS=0.1482p AD=0.1482p
+ PS=1.16u PD=1.16u
M$19 \$16 \$7 vdd vdd sg13_lv_pmos L=0.13u W=0.78u AS=0.1482p AD=0.1482p
+ PS=1.16u PD=1.16u
M$20 vdd \$6 \$7 vdd sg13_lv_pmos L=0.13u W=0.78u AS=0.1482p AD=0.2028p
+ PS=1.16u PD=1.3u
M$21 \$7 \$2 \$8 vdd sg13_lv_pmos L=0.13u W=0.78u AS=0.2028p AD=0.1482p PS=1.3u
+ PD=1.16u
M$22 \$8 \$3 \$17 vdd sg13_lv_pmos L=0.13u W=0.78u AS=0.1482p AD=0.1482p
+ PS=1.16u PD=1.16u
M$23 vdd q \$17 vdd sg13_lv_pmos L=0.13u W=0.78u AS=0.2241p AD=0.1482p PS=1.37u
+ PD=1.16u
M$24 vdd \$8 q vdd sg13_lv_pmos L=0.13u W=0.82u AS=0.2241p AD=0.2788p PS=1.37u
+ PD=2.32u
.ENDS dff_x1

.SUBCKT buf_x2 vdd vss i q
M$1 \$1 i vss vss sg13_lv_nmos L=0.13u W=0.78u AS=0.2652p AD=0.2092p PS=2.24u
+ PD=1.48u
M$2 vss \$1 q vss sg13_lv_nmos L=0.13u W=2.14u AS=0.4125p AD=0.5671p PS=2.93u
+ PD=4.27u
M$4 vdd i \$1 vdd sg13_lv_pmos L=0.13u W=0.78u AS=0.2075p AD=0.2652p PS=1.47u
+ PD=2.24u
M$5 vdd \$1 q vdd sg13_lv_pmos L=0.13u W=2.12u AS=0.4089p AD=0.5618p PS=2.91u
+ PD=4.24u
.ENDS buf_x2

.SUBCKT nand2_x0 vss vdd i0 nq i1
M$1 vss i0 \$6 vss sg13_lv_nmos L=0.13u W=0.78u AS=0.2652p AD=0.1482p PS=2.24u
+ PD=1.16u
M$2 \$6 i1 nq vss sg13_lv_nmos L=0.13u W=0.78u AS=0.1482p AD=0.2808p PS=1.16u
+ PD=2.28u
M$3 vdd i0 nq vdd sg13_lv_pmos L=0.13u W=0.78u AS=0.2652p AD=0.1482p PS=2.24u
+ PD=1.16u
M$4 nq i1 vdd vdd sg13_lv_pmos L=0.13u W=0.78u AS=0.1482p AD=0.2808p PS=1.16u
+ PD=2.28u
.ENDS nand2_x0

.SUBCKT inv_x0 vss vdd nq i
M$1 vss i nq vss sg13_lv_nmos L=0.13u W=0.78u AS=0.2652p AD=0.2652p PS=2.24u
+ PD=2.24u
M$2 vdd i nq vdd sg13_lv_pmos L=0.13u W=0.78u AS=0.2652p AD=0.2652p PS=2.24u
+ PD=2.24u
.ENDS inv_x0
