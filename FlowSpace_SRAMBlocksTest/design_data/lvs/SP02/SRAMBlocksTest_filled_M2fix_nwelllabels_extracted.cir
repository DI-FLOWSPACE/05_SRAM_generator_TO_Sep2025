* Extracted by KLayout with SG13G2 LVS runset on : 24/10/2025 17:08

.SUBCKT SP02 vss in_srout vdd_block vdd_periph out_srout out_latch clk in_shift
+ out_srin out_l2s out_shift in_latch in_srin
X$2 vss out_l2s out_shift out_srout vdd_periph out_srin clk out_latch in_latch
+ in_shift in_srin in_srout vdd_block SP6TBlock_256x16_332A2WE_Test
.ENDS SP02

.SUBCKT SP6TBlock_256x16_332A2WE_Test vss out_l2s out_shift out_srout
+ vdd_periph out_srin clk out_latch in_latch in_shift in_srin in_srout vdd_block
X$1 vss clk \$44 \$14 \$45 \$15 \$46 \$16 \$47 \$17 \$61 \$18 \$48 \$19 \$49
+ \$20 \$50 \$21 \$51 \$52 \$22 \$53 \$23 \$54 \$24 \$55 \$25 \$56 \$26 \$57
+ \$27 \$58 \$28 \$59 \$29 \$60 \$42 \$43 vdd_block \$37 \$38 \$39 \$40 \$41
+ \$36 SP6TBlock_256x16_332A2WE
X$2 vss in_shift \$32 vdd_periph \$33 in_latch \$44 \$45 \$46 \$47 \$61 \$48
+ \$49 \$50 \$51 SP6TTimingIn_9SL
X$3 vss out_shift out_l2s \$6 vdd_periph \$5 out_latch \$14 \$15 \$16 \$17 \$18
+ \$19 \$20 \$21 SP6TTimingOut_8SL
X$4 vss in_shift \$33 vdd_periph in_srout in_latch \$52 \$53 \$54 \$55 \$56
+ \$57 \$58 \$59 \$60 SP6TTimingIn_9SL
X$5 vss out_shift out_l2s out_srout vdd_periph \$6 out_latch \$22 \$23 \$24
+ \$25 \$26 \$27 \$28 \$29 SP6TTimingOut_8SL
X$6 vss in_shift in_srin vdd_periph \$32 in_latch \$36 \$37 \$38 \$39 \$40 \$41
+ \$42 \$43 SP6TTimingIn_8SF
X$10 vss vdd_periph out_shift out_l2s in_latch out_latch clk out_srin \$5
+ SP6TTimingOut_2SL
.ENDS SP6TBlock_256x16_332A2WE_Test

.SUBCKT SP6TTimingOut_2SL vss vdd sr_shift l2s o[0] o[1] sr_latch sr_in sr_out
X$1 vss \$11 \$10 sr_shift vdd dff_x1
X$2 vss o[0] \$12 sr_latch vdd dff_x1
X$3 vdd vss l2s sr_in \$12 \$11 mux2_x1
X$4 vdd vss l2s \$10 \$15 \$14 mux2_x1
X$5 vss \$14 sr_out sr_shift vdd dff_x1
X$6 vss o[1] \$15 sr_latch vdd dff_x1
.ENDS SP6TTimingOut_2SL

.SUBCKT SP6TTimingOut_8SL vss sr_shift l2s sr_out vdd sr_in sr_latch o[0] o[1]
+ o[2] o[3] o[4] o[5] o[6] o[7]
X$1 vss \$9 \$10 sr_shift vdd dff_x1
X$2 vss o[0] \$25 sr_latch vdd dff_x1
X$3 vdd vss l2s sr_in \$25 \$9 mux2_x1
X$4 vdd vss l2s \$10 \$5 \$11 mux2_x1
X$5 vss \$11 \$12 sr_shift vdd dff_x1
X$6 vss o[1] \$5 sr_latch vdd dff_x1
X$7 vss \$13 \$14 sr_shift vdd dff_x1
X$8 vss o[2] \$26 sr_latch vdd dff_x1
X$9 vdd vss l2s \$12 \$26 \$13 mux2_x1
X$10 vdd vss l2s \$14 \$6 \$15 mux2_x1
X$11 vss \$15 \$16 sr_shift vdd dff_x1
X$12 vss o[3] \$6 sr_latch vdd dff_x1
X$13 vss \$17 \$18 sr_shift vdd dff_x1
X$14 vss o[4] \$28 sr_latch vdd dff_x1
X$15 vdd vss l2s \$16 \$28 \$17 mux2_x1
X$16 vdd vss l2s \$18 \$7 \$19 mux2_x1
X$17 vss \$19 \$20 sr_shift vdd dff_x1
X$18 vss o[5] \$7 sr_latch vdd dff_x1
X$19 vss \$21 \$22 sr_shift vdd dff_x1
X$20 vss o[6] \$29 sr_latch vdd dff_x1
X$21 vdd vss l2s \$20 \$29 \$21 mux2_x1
X$22 vdd vss l2s \$22 \$8 \$23 mux2_x1
X$23 vss \$23 sr_out sr_shift vdd dff_x1
X$24 vss o[7] \$8 sr_latch vdd dff_x1
.ENDS SP6TTimingOut_8SL

.SUBCKT SP6TTimingIn_9SL vss sr_shift sr_in vdd sr_out sr_latch i[0] i[1] i[2]
+ i[3] i[4] i[5] i[6] i[7] i[8]
X$1 vss sr_in \$5 sr_shift vdd dff_x1
X$2 vss \$5 i[0] sr_latch vdd dff_x1
X$3 vss \$5 \$6 sr_shift vdd dff_x1
X$4 vss \$6 i[1] sr_latch vdd dff_x1
X$5 vss \$6 \$7 sr_shift vdd dff_x1
X$6 vss \$7 i[2] sr_latch vdd dff_x1
X$7 vss \$7 \$8 sr_shift vdd dff_x1
X$8 vss \$8 i[3] sr_latch vdd dff_x1
X$9 vss \$8 \$9 sr_shift vdd dff_x1
X$10 vss \$9 i[4] sr_latch vdd dff_x1
X$11 vss \$9 \$10 sr_shift vdd dff_x1
X$12 vss \$10 i[5] sr_latch vdd dff_x1
X$13 vss \$10 \$11 sr_shift vdd dff_x1
X$14 vss \$11 i[6] sr_latch vdd dff_x1
X$15 vss \$11 \$12 sr_shift vdd dff_x1
X$16 vss \$12 i[7] sr_latch vdd dff_x1
X$17 vss \$12 sr_out sr_shift vdd dff_x1
X$18 vss sr_out i[8] sr_latch vdd dff_x1
.ENDS SP6TTimingIn_9SL

.SUBCKT SP6TTimingIn_8SF vss sr_shift sr_in vdd sr_out sr_latch i[7] i[6] i[5]
+ i[4] i[3] i[2] i[1] i[0]
X$1 vss sr_in \$5 sr_shift vdd dff_x1
X$2 vss \$5 i[7] sr_latch vdd dff_x1
X$3 vss \$5 \$6 sr_shift vdd dff_x1
X$4 vss \$6 i[6] sr_latch vdd dff_x1
X$5 vss \$6 \$7 sr_shift vdd dff_x1
X$6 vss \$7 i[5] sr_latch vdd dff_x1
X$7 vss \$7 \$8 sr_shift vdd dff_x1
X$8 vss \$8 i[4] sr_latch vdd dff_x1
X$9 vss \$8 \$9 sr_shift vdd dff_x1
X$10 vss \$9 i[3] sr_latch vdd dff_x1
X$11 vss \$9 \$10 sr_shift vdd dff_x1
X$12 vss \$10 i[2] sr_latch vdd dff_x1
X$13 vss \$10 \$11 sr_shift vdd dff_x1
X$14 vss \$11 i[1] sr_latch vdd dff_x1
X$15 vss \$11 sr_out sr_shift vdd dff_x1
X$16 vss sr_out i[0] sr_latch vdd dff_x1
.ENDS SP6TTimingIn_8SF

.SUBCKT SP6TBlock_256x16_332A2WE vss clk d[0] q[0] d[1] q[1] d[2] q[2] d[3]
+ q[3] d[4] q[4] d[5] q[5] d[6] q[6] d[7] q[7] we[0] d[8] q[8] d[9] q[9] d[10]
+ q[10] d[11] q[11] d[12] q[12] d[13] q[13] d[14] q[14] d[15] q[15] we[1] a[1]
+ a[0] vdd a[6] a[5] a[4] a[3] a[2] a[7]
X$1 vss clk \$38 \$37 vdd \$41 a[0] \$48 \$49 a[1] \$47 \$46 a[2] \$76 \$74
+ \$73 \$72 a[3] \$65 \$66 \$67 \$63 \$94 \$69 \$70 \$61 a[4] \$78 \$93 \$92
+ \$88 \$89 \$90 \$81 \$86 \$71 \$82 \$79 \$80 \$83 \$84 a[5] \$87 \$68 \$64
+ \$62 \$91 \$85 a[6] \$118 \$75 \$77 \$111 \$116 \$117 a[7] \$122 \$121 \$123
+ \$115 \$119 \$120 \$114 \$106 \$113 \$112 \$108 \$110 \$103 \$104 \$100 \$107
+ \$109 \$105 \$102 \$128 \$127 \$126 \$125 \$101 \$129 \$124
+ SP6TRowPeriphery_3_3_2
X$2 vss d[0] q[0] d[1] q[1] d[2] q[2] d[3] q[3] d[4] q[4] d[5] q[5] d[6] q[6]
+ d[7] q[7] we[0] d[8] q[8] d[9] q[9] d[10] q[10] d[11] q[11] \$38 \$37 d[12]
+ q[12] d[13] q[13] d[14] q[14] d[15] q[15] we[1] \$47 \$46 \$41 vdd \$49 \$48
+ \$78 \$63 \$91 \$62 \$64 \$87 \$94 \$93 \$85 \$80 \$92 \$90 \$79 \$71 \$89
+ \$88 \$86 \$84 \$83 \$81 \$82 \$66 \$65 \$76 \$74 \$73 \$72 \$61 \$70 \$69
+ \$67 \$100 \$122 \$123 \$115 \$114 \$112 \$110 \$108 \$106 \$105 \$102 \$113
+ \$103 \$104 \$107 \$109 \$101 \$129 \$124 \$125 \$77 \$117 \$116 \$118 \$111
+ \$119 \$75 \$120 \$68 \$121 \$128 \$127 \$126 SP6TColumnBlock_64R16B4M2W
.ENDS SP6TBlock_256x16_332A2WE

.SUBCKT mux2_x1 vdd vss cmd i0 i1 q
M$1 \$1 cmd vss vss sg13_lv_nmos L=0.13u W=0.78u AS=0.2652p AD=0.1482p PS=2.24u
+ PD=1.16u
M$2 vss i0 \$11 vss sg13_lv_nmos L=0.13u W=0.78u AS=0.1482p AD=0.1482p PS=1.16u
+ PD=1.16u
M$3 \$11 \$1 \$6 vss sg13_lv_nmos L=0.13u W=0.78u AS=0.1482p AD=0.195p PS=1.16u
+ PD=1.28u
M$4 \$6 cmd \$12 vss sg13_lv_nmos L=0.13u W=0.78u AS=0.195p AD=0.1482p PS=1.28u
+ PD=1.16u
M$5 \$12 i1 vss vss sg13_lv_nmos L=0.13u W=0.78u AS=0.1482p AD=0.2092p PS=1.16u
+ PD=1.48u
M$6 vss \$6 q vss sg13_lv_nmos L=0.13u W=1.07u AS=0.2092p AD=0.3638p PS=1.48u
+ PD=2.82u
M$7 \$1 cmd vdd vdd sg13_lv_pmos L=0.13u W=0.78u AS=0.2652p AD=0.1482p PS=2.24u
+ PD=1.16u
M$8 vdd i0 \$9 vdd sg13_lv_pmos L=0.13u W=0.78u AS=0.1482p AD=0.1482p PS=1.16u
+ PD=1.16u
M$9 \$9 cmd \$6 vdd sg13_lv_pmos L=0.13u W=0.78u AS=0.1482p AD=0.195p PS=1.16u
+ PD=1.28u
M$10 \$6 \$1 \$10 vdd sg13_lv_pmos L=0.13u W=0.78u AS=0.195p AD=0.1482p
+ PS=1.28u PD=1.16u
M$11 vdd i1 \$10 vdd sg13_lv_pmos L=0.13u W=0.78u AS=0.2075p AD=0.1482p
+ PS=1.47u PD=1.16u
M$12 vdd \$6 q vdd sg13_lv_pmos L=0.13u W=1.06u AS=0.2075p AD=0.3604p PS=1.47u
+ PD=2.8u
.ENDS mux2_x1

.SUBCKT SP6TColumnBlock_64R16B4M2W vss d[0] q[0] d[1] q[1] d[2] q[2] d[3] q[3]
+ d[4] q[4] d[5] q[5] d[6] q[6] d[7] q[7] we[0] d[8] q[8] d[9] q[9] d[10] q[10]
+ d[11] q[11] clk we_en d[12] q[12] d[13] q[13] d[14] q[14] d[15] q[15] we[1]
+ mux[2] mux[3] precharge_n vdd mux[1] mux[0] wl[12] wl[10] wl[28] wl[29]
+ wl[30] wl[27] wl[11] wl[13] wl[26] wl[25] wl[14] wl[15] wl[24] wl[23] wl[16]
+ wl[17] wl[18] wl[19] wl[20] wl[22] wl[21] wl[8] wl[9] wl[0] wl[1] wl[2] wl[3]
+ wl[4] wl[5] wl[6] wl[7] wl[52] wl[41] wl[42] wl[43] wl[44] wl[46] wl[47]
+ wl[48] wl[49] wl[50] wl[51] wl[45] wl[53] wl[54] wl[55] wl[56] wl[57] wl[58]
+ wl[59] wl[60] wl[33] wl[36] wl[35] wl[37] wl[34] wl[38] wl[32] wl[39] wl[31]
+ wl[40] wl[63] wl[62] wl[61]
X$1 vss d[8] q[8] d[9] q[9] d[10] q[10] d[11] q[11] d[12] q[12] d[13] q[13]
+ d[14] q[14] d[15] q[15] we[1] clk we_en vdd mux[0] wl[11] wl[6] wl[13] wl[3]
+ wl[2] wl[12] wl[7] wl[1] wl[0] wl[5] wl[10] wl[4] wl[9] wl[8] wl[24] wl[25]
+ wl[26] wl[27] wl[28] wl[29] wl[30] wl[31] wl[15] wl[32] wl[33] wl[34] wl[35]
+ wl[36] wl[37] wl[22] wl[14] precharge_n mux[3] wl[16] mux[2] mux[1] wl[17]
+ wl[18] wl[19] wl[20] wl[21] wl[23] wl[45] wl[46] wl[47] wl[38] wl[48] wl[49]
+ wl[50] wl[51] wl[52] wl[53] wl[43] wl[42] wl[41] wl[40] wl[39] wl[44] wl[62]
+ wl[63] wl[61] wl[60] wl[59] wl[58] wl[57] wl[55] wl[54] wl[56]
+ SP6TColumn_64R8B4M
X$2 vss d[0] q[0] d[1] q[1] d[2] q[2] d[3] q[3] d[4] q[4] d[5] q[5] d[6] q[6]
+ d[7] q[7] we[0] clk we_en vdd mux[0] wl[11] wl[6] wl[13] wl[3] wl[2] wl[12]
+ wl[7] wl[1] wl[0] wl[5] wl[10] wl[4] wl[9] wl[8] wl[24] wl[25] wl[26] wl[27]
+ wl[28] wl[29] wl[30] wl[31] wl[15] wl[32] wl[33] wl[34] wl[35] wl[36] wl[37]
+ wl[22] wl[14] precharge_n mux[3] wl[16] mux[2] mux[1] wl[17] wl[18] wl[19]
+ wl[20] wl[21] wl[23] wl[45] wl[46] wl[47] wl[38] wl[48] wl[49] wl[50] wl[51]
+ wl[52] wl[53] wl[43] wl[42] wl[41] wl[40] wl[39] wl[44] wl[62] wl[63] wl[61]
+ wl[60] wl[59] wl[58] wl[57] wl[55] wl[54] wl[56] SP6TColumn_64R8B4M
.ENDS SP6TColumnBlock_64R16B4M2W

.SUBCKT SP6TRowPeriphery_3_3_2 vss clk columnclk we_en vdd precharge_n a[0]
+ mux[0] mux[1] a[1] mux[2] mux[3] a[2] wl[0] wl[1] wl[2] wl[3] a[3] wl[9]
+ wl[8] wl[7] wl[10] wl[11] wl[6] wl[5] wl[4] a[4] wl[12] wl[13] wl[14] wl[17]
+ wl[16] wl[15] wl[22] wl[18] wl[23] wl[21] wl[24] wl[25] wl[20] wl[19] a[5]
+ wl[27] wl[31] wl[30] wl[29] wl[28] wl[26] a[6] wl[37] wl[32] wl[33] wl[34]
+ wl[35] wl[36] a[7] wl[41] wl[40] wl[42] wl[43] wl[38] wl[39] wl[44] wl[49]
+ wl[45] wl[46] wl[48] wl[47] wl[53] wl[54] wl[52] wl[55] wl[56] wl[50] wl[51]
+ wl[63] wl[62] wl[61] wl[60] wl[57] wl[58] wl[59]
X$1 vss vdd clk \$7 wl_en precharge_n columnclk we_en SP6TClockGenerator_8S1R
X$2 vss vdd a[2] wl[0] wl[1] wl[2] wl[3] wl[4] wl[5] wl[6] wl[7] wl[8] a[3]
+ wl[10] wl[9] wl[12] wl[11] wl[13] wl[14] wl[15] a[4] wl[17] wl[16] wl[18]
+ wl[19] \$7 wl[21] wl[20] wl[22] wl[24] wl[23] a[5] wl[26] wl[25] wl_en wl[29]
+ wl[28] wl[27] wl[30] wl[31] a[6] wl[32] wl[34] wl[33] wl[36] wl[37] wl[35]
+ wl[40] wl[39] wl[38] a[7] wl[43] wl[42] wl[41] wl[45] wl[44] wl[47] wl[46]
+ wl[48] wl[49] wl[52] wl[51] wl[50] wl[53] wl[55] wl[54] wl[58] wl[59] wl[56]
+ wl[57] wl[60] wl[61] wl[63] wl[62] SP6TRowDecoder_3_3B
X$3 vss vdd a[0] a[1] mux[0] mux[1] mux[2] mux[3] \$7 SP6TLatchedDecoder_2A2R
.ENDS SP6TRowPeriphery_3_3_2

.SUBCKT SP6TColumn_64R8B4M vss d[0] q[0] d[1] q[1] d[2] q[2] d[3] q[3] d[4]
+ q[4] d[5] q[5] d[6] q[6] d[7] q[7] we clk we_en vdd mux[0] wl[11] wl[6]
+ wl[13] wl[3] wl[2] wl[12] wl[7] wl[1] wl[0] wl[5] wl[10] wl[4] wl[9] wl[8]
+ wl[24] wl[25] wl[26] wl[27] wl[28] wl[29] wl[30] wl[31] wl[15] wl[32] wl[33]
+ wl[34] wl[35] wl[36] wl[37] wl[22] wl[14] precharge_n mux[3] wl[16] mux[2]
+ mux[1] wl[17] wl[18] wl[19] wl[20] wl[21] wl[23] wl[45] wl[46] wl[47] wl[38]
+ wl[48] wl[49] wl[50] wl[51] wl[52] wl[53] wl[43] wl[42] wl[41] wl[40] wl[39]
+ wl[44] wl[62] wl[63] wl[61] wl[60] wl[59] wl[58] wl[57] wl[55] wl[54] wl[56]
X$1 vss we d[0] d[1] vdd d[2] d[3] d[4] d[5] d[6] clk d[7] we_en q[0] q[1] q[2]
+ q[3] q[4] q[5] q[6] q[7] bl[0] bl_n[0] bl_n[1] bl[1] bl[2] bl_n[2] bl_n[3]
+ bl[3] bl[4] bl_n[4] bl_n[5] bl[5] bl[6] bl_n[6] bl_n[7] bl[7] bl[8] bl_n[8]
+ bl_n[9] bl[9] bl[10] bl_n[10] bl_n[11] bl[11] bl[12] bl_n[12] bl_n[13] bl[13]
+ bl[14] bl_n[14] bl_n[15] bl[15] mux[0] bl[16] bl_n[16] bl_n[17] bl[17] bl[18]
+ bl_n[18] bl_n[19] bl[19] bl[20] bl_n[20] bl_n[21] bl[21] bl[22] bl_n[22]
+ bl_n[23] bl[23] bl[24] bl_n[24] bl_n[25] bl[25] bl[26] bl_n[26] bl_n[27]
+ bl[27] bl[28] bl_n[28] bl_n[29] bl[29] bl[30] bl_n[30] bl_n[31] bl[31] mux[3]
+ mux[1] precharge_n mux[2] vdd SP6TColumnPeriphery_8B4M
X$2 vss bl[0] bl_n[0] bl_n[1] bl[1] bl[2] bl_n[2] bl_n[3] bl[3] bl[4] bl_n[4]
+ bl_n[5] bl[5] bl[6] bl_n[6] bl_n[7] bl[7] bl[8] bl_n[8] bl_n[9] bl[9] bl[10]
+ bl_n[10] bl_n[11] bl[11] bl[12] bl_n[12] bl_n[13] bl[13] bl[14] bl_n[14]
+ bl_n[15] bl[15] wl[17] wl[16] wl[26] wl[18] wl[19] wl[20] wl[21] wl[22]
+ wl[23] wl[31] wl[30] wl[29] wl[24] wl[28] wl[27] wl[25] wl[15] vdd wl[0]
+ wl[1] wl[2] wl[3] wl[4] wl[5] wl[7] wl[8] wl[9] wl[10] wl[11] wl[12] wl[13]
+ wl[14] wl[6] bl[16] bl_n[16] bl_n[17] bl[17] bl[18] bl_n[18] bl_n[19] bl[19]
+ bl[20] bl_n[20] bl_n[21] bl[21] bl[22] bl_n[22] bl_n[23] bl[23] bl[24]
+ bl_n[24] bl_n[25] bl[25] bl[26] bl_n[26] bl_n[27] bl[27] bl[28] bl_n[28]
+ bl_n[29] bl[29] bl[30] bl_n[30] bl_n[31] bl[31] wl[62] wl[53] wl[54] wl[55]
+ wl[56] wl[57] wl[58] wl[59] wl[60] wl[61] wl[48] wl[63] wl[40] wl[44] wl[41]
+ wl[43] wl[42] wl[38] wl[33] wl[32] wl[35] wl[36] wl[37] wl[47] wl[52] wl[46]
+ wl[39] wl[45] wl[34] wl[49] wl[50] wl[51] SP6TArray_64X32BC
.ENDS SP6TColumn_64R8B4M

.SUBCKT SP6TClockGenerator_8S1R vss vdd clk decodeclk wl_en precharge_n
+ columnclk we_en
X$1 vdd vss \$7 wl_en buf_x1
X$2 vdd vss clk decodeclk buf_x1
X$3 vss vdd precharge_n \$10 inv_x1
X$4 vdd vss clk columnclk buf_x1
X$5 vss vdd \$7 \$10 clk SP6TNonOverlapClock_8S1R
X$6 vdd vss \$7 we_en buf_x1
.ENDS SP6TClockGenerator_8S1R

.SUBCKT SP6TLatchedDecoder_2A2R vss vdd a[0] a[1] line[0] line[1] line[2]
+ line[3] clk
X$1 vss a[0] \$11 clk vdd SP6TDec_dff_x1
X$2 vss a[1] \$12 clk vdd SP6TDec_dff_x1
X$3 vss vdd \$13 \$11 SP6TDec_inv_x1
X$4 vss vdd \$13 \$16 \$14 SP6TDec_nand2_x0
X$5 vss vdd line[0] \$16 SP6TDec_inv_x2
X$6 vss vdd \$11 \$17 \$14 SP6TDec_nand2_x0
X$7 vss vdd line[1] \$17 SP6TDec_inv_x2
X$8 vss vdd \$13 \$18 \$12 SP6TDec_nand2_x0
X$9 vss vdd \$14 \$12 SP6TDec_inv_x1
X$10 vss vdd line[2] \$18 SP6TDec_inv_x2
X$11 vss vdd \$11 \$19 \$12 SP6TDec_nand2_x0
X$12 vss vdd line[3] \$19 SP6TDec_inv_x2
.ENDS SP6TLatchedDecoder_2A2R

.SUBCKT SP6TRowDecoder_3_3B vss vdd a[0] wl[0] wl[1] wl[2] wl[3] wl[4] wl[5]
+ wl[6] wl[7] wl[8] a[1] wl[10] wl[9] wl[12] wl[11] wl[13] wl[14] wl[15] a[2]
+ wl[17] wl[16] wl[18] wl[19] clk wl[21] wl[20] wl[22] wl[24] wl[23] a[3]
+ wl[26] wl[25] wl_en wl[29] wl[28] wl[27] wl[30] wl[31] a[4] wl[32] wl[34]
+ wl[33] wl[36] wl[37] wl[35] wl[40] wl[39] wl[38] a[5] wl[43] wl[42] wl[41]
+ wl[45] wl[44] wl[47] wl[46] wl[48] wl[49] wl[52] wl[51] wl[50] wl[53] wl[55]
+ wl[54] wl[58] wl[59] wl[56] wl[57] wl[60] wl[61] wl[63] wl[62]
X$1 vss vdd \$6 \$13 \$2 \$9 \$27 \$10 \$16 \$41 \$12 \$49 \$20 \$17 \$65 \$74
+ \$87 \$99 clk a[0] a[1] a[2] a[3] a[4] a[5] SP6TRowPredecoders_3_3B
X$3 vss \$2 \$6 wl[0] wl[1] vdd \$10 \$9 wl[2] wl_en wl[3] \$12 \$16 wl[4]
+ wl[5] \$17 \$20 wl[6] \$13 wl[7] SP6TRowDecoderDriverPage_2PD8R
X$4 vss \$2 \$6 wl[8] wl[9] vdd \$10 \$9 wl[10] wl_en wl[11] \$12 \$16 wl[12]
+ wl[13] \$17 \$20 wl[14] \$27 wl[15] SP6TRowDecoderDriverPage_2PD8R
X$6 vss \$2 \$6 wl[16] wl[17] vdd \$10 \$9 wl[18] wl_en wl[19] \$12 \$16 wl[20]
+ wl[21] \$17 \$20 wl[22] \$41 wl[23] SP6TRowDecoderDriverPage_2PD8R
X$7 vss \$2 \$6 wl[24] wl[25] vdd \$10 \$9 wl[26] wl_en wl[27] \$12 \$16 wl[28]
+ wl[29] \$17 \$20 wl[30] \$49 wl[31] SP6TRowDecoderDriverPage_2PD8R
X$9 vss \$2 \$6 wl[32] wl[33] vdd \$10 \$9 wl[34] wl_en wl[35] \$12 \$16 wl[36]
+ wl[37] \$17 \$20 wl[38] \$65 wl[39] SP6TRowDecoderDriverPage_2PD8R
X$10 vss \$2 \$6 wl[40] wl[41] vdd \$10 \$9 wl[42] wl_en wl[43] \$12 \$16
+ wl[44] wl[45] \$17 \$20 wl[46] \$74 wl[47] SP6TRowDecoderDriverPage_2PD8R
X$12 vss \$2 \$6 wl[48] wl[49] vdd \$10 \$9 wl[50] wl_en wl[51] \$12 \$16
+ wl[52] wl[53] \$17 \$20 wl[54] \$87 wl[55] SP6TRowDecoderDriverPage_2PD8R
X$13 vss \$2 \$6 wl[56] wl[57] vdd \$10 \$9 wl[58] wl_en wl[59] \$12 \$16
+ wl[60] wl[61] \$17 \$20 wl[62] \$99 wl[63] SP6TRowDecoderDriverPage_2PD8R
.ENDS SP6TRowDecoder_3_3B

.SUBCKT SP6TArray_64X32BC vss bl[0] bl_n[0] bl_n[1] bl[1] bl[2] bl_n[2] bl_n[3]
+ bl[3] bl[4] bl_n[4] bl_n[5] bl[5] bl[6] bl_n[6] bl_n[7] bl[7] bl[8] bl_n[8]
+ bl_n[9] bl[9] bl[10] bl_n[10] bl_n[11] bl[11] bl[12] bl_n[12] bl_n[13] bl[13]
+ bl[14] bl_n[14] bl_n[15] bl[15] wl[17] wl[16] wl[26] wl[18] wl[19] wl[20]
+ wl[21] wl[22] wl[23] wl[31] wl[30] wl[29] wl[24] wl[28] wl[27] wl[25] wl[15]
+ vdd wl[0] wl[1] wl[2] wl[3] wl[4] wl[5] wl[7] wl[8] wl[9] wl[10] wl[11]
+ wl[12] wl[13] wl[14] wl[6] bl[16] bl_n[16] bl_n[17] bl[17] bl[18] bl_n[18]
+ bl_n[19] bl[19] bl[20] bl_n[20] bl_n[21] bl[21] bl[22] bl_n[22] bl_n[23]
+ bl[23] bl[24] bl_n[24] bl_n[25] bl[25] bl[26] bl_n[26] bl_n[27] bl[27] bl[28]
+ bl_n[28] bl_n[29] bl[29] bl[30] bl_n[30] bl_n[31] bl[31] wl[62] wl[53] wl[54]
+ wl[55] wl[56] wl[57] wl[58] wl[59] wl[60] wl[61] wl[48] wl[63] wl[40] wl[44]
+ wl[41] wl[43] wl[42] wl[38] wl[33] wl[32] wl[35] wl[36] wl[37] wl[47] wl[52]
+ wl[46] wl[39] wl[45] wl[34] wl[49] wl[50] wl[51]
X$2 vss bl[0] bl_n[0] bl_n[1] bl[1] bl[2] bl_n[2] bl_n[3] bl[3] bl[4] bl_n[4]
+ bl_n[5] bl[5] bl[6] bl_n[6] bl_n[7] bl[7] bl[8] bl_n[8] bl_n[9] bl[9] bl[10]
+ bl_n[10] bl_n[11] bl[11] bl[12] bl_n[12] bl_n[13] bl[13] bl[14] bl_n[14]
+ bl_n[15] bl[15] wl[7] wl[8] wl[6] wl[9] wl[5] wl[10] wl[4] wl[11] wl[3] wl[2]
+ wl[1] wl[0] wl[12] wl[13] wl[14] wl[15] bl[16] bl_n[16] bl_n[17] bl[17]
+ bl[18] bl_n[18] bl_n[19] bl[19] bl[20] bl_n[20] bl_n[21] bl[21] bl[22]
+ bl_n[22] bl_n[23] bl[23] bl[24] bl_n[24] bl_n[25] bl[25] bl[26] bl_n[26]
+ bl_n[27] bl[27] bl[28] bl_n[28] bl_n[29] bl[29] bl[30] bl_n[30] bl_n[31]
+ bl[31] wl[31] wl[30] wl[29] wl[28] wl[27] wl[26] wl[25] vdd wl[16] wl[24]
+ wl[17] wl[18] wl[19] wl[20] wl[21] wl[22] wl[23] SP6TArray_32X32
X$4 vss bl[0] bl_n[0] bl_n[1] bl[1] bl[2] bl_n[2] bl_n[3] bl[3] bl[4] bl_n[4]
+ bl_n[5] bl[5] bl[6] bl_n[6] bl_n[7] bl[7] bl[8] bl_n[8] bl_n[9] bl[9] bl[10]
+ bl_n[10] bl_n[11] bl[11] bl[12] bl_n[12] bl_n[13] bl[13] bl[14] bl_n[14]
+ bl_n[15] bl[15] wl[39] wl[40] wl[38] wl[41] wl[37] wl[42] wl[36] wl[43]
+ wl[35] wl[34] wl[33] wl[32] wl[44] wl[45] wl[46] wl[47] bl[16] bl_n[16]
+ bl_n[17] bl[17] bl[18] bl_n[18] bl_n[19] bl[19] bl[20] bl_n[20] bl_n[21]
+ bl[21] bl[22] bl_n[22] bl_n[23] bl[23] bl[24] bl_n[24] bl_n[25] bl[25] bl[26]
+ bl_n[26] bl_n[27] bl[27] bl[28] bl_n[28] bl_n[29] bl[29] bl[30] bl_n[30]
+ bl_n[31] bl[31] wl[63] wl[62] wl[61] wl[60] wl[59] wl[58] wl[57] vdd wl[48]
+ wl[56] wl[49] wl[50] wl[51] wl[52] wl[53] wl[54] wl[55] SP6TArray_32X32
.ENDS SP6TArray_64X32BC

.SUBCKT SP6TColumnPeriphery_8B4M vss we d[0] d[1] vdd d[2] d[3] d[4] d[5] d[6]
+ clk d[7] we_en q[0] q[1] q[2] q[3] q[4] q[5] q[6] q[7] bl[0] bl_n[0] bl_n[1]
+ bl[1] bl[2] bl_n[2] bl_n[3] bl[3] bl[4] bl_n[4] bl_n[5] bl[5] bl[6] bl_n[6]
+ bl_n[7] bl[7] bl[8] bl_n[8] bl_n[9] bl[9] bl[10] bl_n[10] bl_n[11] bl[11]
+ bl[12] bl_n[12] bl_n[13] bl[13] bl[14] bl_n[14] bl_n[15] bl[15] mux[0] bl[16]
+ bl_n[16] bl_n[17] bl[17] bl[18] bl_n[18] bl_n[19] bl[19] bl[20] bl_n[20]
+ bl_n[21] bl[21] bl[22] bl_n[22] bl_n[23] bl[23] bl[24] bl_n[24] bl_n[25]
+ bl[25] bl[26] bl_n[26] bl_n[27] bl[27] bl[28] bl_n[28] bl_n[29] bl[29] bl[30]
+ bl_n[30] bl_n[31] bl[31] mux[3] mux[1] precharge_n mux[2] \$I302
X$1 \$103 bl[4] bl_n[4] \$100 bl_n[5] bl[5] bl[6] bl_n[6] bl_n[7] bl[7] mux[0]
+ vss mux[1] mux[2] mux[3] SP6TColMux_4C
X$2 \$93 bl[0] bl_n[0] \$95 bl_n[1] bl[1] bl[2] bl_n[2] bl_n[3] bl[3] mux[0]
+ vss mux[1] mux[2] mux[3] SP6TColMux_4C
X$3 precharge_n vdd bl[0] bl_n[0] \$I302 SP6TPrecharge
X$4 precharge_n vdd bl[1] bl_n[1] \$I302 SP6TPrecharge
X$5 precharge_n vdd bl[2] bl_n[2] \$I302 SP6TPrecharge
X$6 precharge_n vdd bl[3] bl_n[3] \$I302 SP6TPrecharge
X$7 precharge_n vdd bl[4] bl_n[4] \$I302 SP6TPrecharge
X$8 \$107 bl[8] bl_n[8] \$106 bl_n[9] bl[9] bl[10] bl_n[10] bl_n[11] bl[11]
+ mux[0] vss mux[1] mux[2] mux[3] SP6TColMux_4C
X$9 precharge_n vdd bl[5] bl_n[5] \$I302 SP6TPrecharge
X$10 precharge_n vdd bl[6] bl_n[6] \$I302 SP6TPrecharge
X$11 precharge_n vdd bl[7] bl_n[7] \$I302 SP6TPrecharge
X$12 precharge_n vdd bl[8] bl_n[8] \$I302 SP6TPrecharge
X$13 \$104 bl[12] bl_n[12] \$105 bl_n[13] bl[13] bl[14] bl_n[14] bl_n[15]
+ bl[15] mux[0] vss mux[1] mux[2] mux[3] SP6TColMux_4C
X$14 precharge_n vdd bl[9] bl_n[9] \$I302 SP6TPrecharge
X$15 precharge_n vdd bl[10] bl_n[10] \$I302 SP6TPrecharge
X$16 precharge_n vdd bl[11] bl_n[11] \$I302 SP6TPrecharge
X$17 precharge_n vdd bl[12] bl_n[12] \$I302 SP6TPrecharge
X$18 \$101 bl[16] bl_n[16] \$102 bl_n[17] bl[17] bl[18] bl_n[18] bl_n[19]
+ bl[19] mux[0] vss mux[1] mux[2] mux[3] SP6TColMux_4C
X$19 precharge_n vdd bl[13] bl_n[13] \$I302 SP6TPrecharge
X$20 precharge_n vdd bl[14] bl_n[14] \$I302 SP6TPrecharge
X$21 precharge_n vdd bl[15] bl_n[15] \$I302 SP6TPrecharge
X$22 precharge_n vdd bl[16] bl_n[16] \$I302 SP6TPrecharge
X$23 \$99 bl[20] bl_n[20] \$98 bl_n[21] bl[21] bl[22] bl_n[22] bl_n[23] bl[23]
+ mux[0] vss mux[1] mux[2] mux[3] SP6TColMux_4C
X$24 precharge_n vdd bl[17] bl_n[17] \$I302 SP6TPrecharge
X$25 precharge_n vdd bl[18] bl_n[18] \$I302 SP6TPrecharge
X$26 precharge_n vdd bl[19] bl_n[19] \$I302 SP6TPrecharge
X$27 precharge_n vdd bl[20] bl_n[20] \$I302 SP6TPrecharge
X$28 \$96 bl[24] bl_n[24] \$97 bl_n[25] bl[25] bl[26] bl_n[26] bl_n[27] bl[27]
+ mux[0] vss mux[1] mux[2] mux[3] SP6TColMux_4C
X$29 precharge_n vdd bl[21] bl_n[21] \$I302 SP6TPrecharge
X$30 precharge_n vdd bl[22] bl_n[22] \$I302 SP6TPrecharge
X$31 precharge_n vdd bl[23] bl_n[23] \$I302 SP6TPrecharge
X$32 precharge_n vdd bl[24] bl_n[24] \$I302 SP6TPrecharge
X$33 \$94 bl[28] bl_n[28] \$92 bl_n[29] bl[29] bl[30] bl_n[30] bl_n[31] bl[31]
+ mux[0] vss mux[1] mux[2] mux[3] SP6TColMux_4C
X$34 precharge_n vdd bl[25] bl_n[25] \$I302 SP6TPrecharge
X$35 precharge_n vdd bl[26] bl_n[26] \$I302 SP6TPrecharge
X$36 precharge_n vdd bl[27] bl_n[27] \$I302 SP6TPrecharge
X$37 precharge_n vdd bl[28] bl_n[28] \$I302 SP6TPrecharge
X$38 precharge_n vdd bl[29] bl_n[29] \$I302 SP6TPrecharge
X$39 precharge_n vdd bl[30] bl_n[30] \$I302 SP6TPrecharge
X$40 precharge_n vdd bl[31] bl_n[31] \$I302 SP6TPrecharge
X$41 \$93 vss \$95 vdd q[0] d[0] \$23 \$15 SP6TReadWrite_4M
X$42 \$103 vss \$100 vdd q[1] d[1] \$23 \$15 SP6TReadWrite_4M
X$43 \$107 vss \$106 vdd q[2] d[2] \$23 \$15 SP6TReadWrite_4M
X$44 \$104 vss \$105 vdd q[3] d[3] \$23 \$15 SP6TReadWrite_4M
X$45 \$101 vss \$102 vdd q[4] d[4] \$23 \$15 SP6TReadWrite_4M
X$46 \$99 vss \$98 vdd q[5] d[5] \$23 \$15 SP6TReadWrite_4M
X$47 clk we we_en \$15 vss vdd \$23 SP6TClockWE
X$48 \$96 vss \$97 vdd q[6] d[6] \$23 \$15 SP6TReadWrite_4M
X$49 \$94 vss \$92 vdd q[7] d[7] \$23 \$15 SP6TReadWrite_4M
.ENDS SP6TColumnPeriphery_8B4M

.SUBCKT SP6TNonOverlapClock_8S1R vss vdd firststage[7] secondstage[7] clk
X$1 vss vdd secondstage[8] secondstage[7] inv_x0
X$2 vss vdd secondstage[7] secondstage[6] inv_x0
X$3 vss vdd secondstage[6] secondstage[5] inv_x0
X$4 vss vdd secondstage[5] secondstage[4] inv_x0
X$5 vss vdd secondstage[4] secondstage[3] inv_x0
X$6 vss vdd secondstage[3] secondstage[2] inv_x0
X$7 vss vdd secondstage[2] secondstage[1] inv_x0
X$8 vss vdd secondstage[1] secondstage[0] inv_x0
X$9 vss vdd \$23 secondstage[0] firststage[8] nand2_x0
X$10 vss vdd \$23 clk inv_x0
X$11 vss vdd clk firststage[0] secondstage[8] nand2_x0
X$12 vss vdd firststage[1] firststage[0] inv_x0
X$13 vss vdd firststage[2] firststage[1] inv_x0
X$14 vss vdd firststage[3] firststage[2] inv_x0
X$15 vss vdd firststage[4] firststage[3] inv_x0
X$16 vss vdd firststage[5] firststage[4] inv_x0
X$17 vss vdd firststage[6] firststage[5] inv_x0
X$18 vss vdd firststage[7] firststage[6] inv_x0
X$19 vss vdd firststage[8] firststage[7] inv_x0
.ENDS SP6TNonOverlapClock_8S1R

.SUBCKT inv_x1 vss vdd nq i
M$1 vss i nq vss sg13_lv_nmos L=0.13u W=1.46u AS=0.4964p AD=0.4964p PS=3.6u
+ PD=3.6u
M$2 vdd i nq vdd sg13_lv_pmos L=0.13u W=1.45u AS=0.493p AD=0.493p PS=3.58u
+ PD=3.58u
.ENDS inv_x1

.SUBCKT buf_x1 vdd vss i q
M$1 \$1 i vss vss sg13_lv_nmos L=0.13u W=0.78u AS=0.2652p AD=0.2092p PS=2.24u
+ PD=1.48u
M$2 vss \$1 q vss sg13_lv_nmos L=0.13u W=1.07u AS=0.2092p AD=0.3638p PS=1.48u
+ PD=2.82u
M$3 vdd i \$1 vdd sg13_lv_pmos L=0.13u W=0.78u AS=0.2075p AD=0.2652p PS=1.47u
+ PD=2.24u
M$4 vdd \$1 q vdd sg13_lv_pmos L=0.13u W=1.06u AS=0.2075p AD=0.3604p PS=1.47u
+ PD=2.8u
.ENDS buf_x1

.SUBCKT SP6TDec_inv_x2 vss vdd nq i
M$1 vss i nq vss sg13_lv_nmos L=0.13u W=5.6u AS=1.484p AD=1.484p PS=9.46u
+ PD=9.46u
M$3 vdd i nq vdd sg13_lv_pmos L=0.13u W=8.8u AS=2.332p AD=2.332p PS=14.26u
+ PD=14.26u
.ENDS SP6TDec_inv_x2

.SUBCKT SP6TDec_nand2_x0 vss vdd i0 nq i1
M$1 vss i0 \$6 vss sg13_lv_nmos L=0.13u W=0.78u AS=0.2652p AD=0.1482p PS=2.24u
+ PD=1.16u
M$2 \$6 i1 nq vss sg13_lv_nmos L=0.13u W=0.78u AS=0.1482p AD=0.312p PS=1.16u
+ PD=2.36u
M$3 vdd i0 nq vdd sg13_lv_pmos L=0.13u W=1.2u AS=0.408p AD=0.228p PS=3.08u
+ PD=1.58u
M$4 nq i1 vdd vdd sg13_lv_pmos L=0.13u W=1.2u AS=0.228p AD=0.48p PS=1.58u
+ PD=3.2u
.ENDS SP6TDec_nand2_x0

.SUBCKT SP6TRowDecoderDriverPage_2PD8R vss pd[0][1] pd[0][0] wl[0] wl[1] vdd
+ pd[0][3] pd[0][2] wl[2] wl_en wl[3] pd[0][5] pd[0][4] wl[4] wl[5] pd[0][7]
+ pd[0][6] wl[6] page wl[7]
X$1 wl[1] vss \$10 vdd vss vdd SP6TWLDrive_26LN100WN26LP200WP
X$2 wl[0] vss \$3 vdd vss vdd SP6TWLDrive_26LN100WN26LP200WP
X$3 wl[2] vss \$9 vdd vss vdd SP6TWLDrive_26LN100WN26LP200WP
X$4 wl[3] vss \$17 vdd vss vdd SP6TWLDrive_26LN100WN26LP200WP
X$5 wl[4] vss \$19 vdd vss vdd SP6TWLDrive_26LN100WN26LP200WP
X$6 wl[5] vss \$23 vdd vss vdd SP6TWLDrive_26LN100WN26LP200WP
X$7 wl[6] vss \$24 vdd vss vdd SP6TWLDrive_26LN100WN26LP200WP
X$8 wl[7] vss \$31 vdd vss vdd SP6TWLDrive_26LN100WN26LP200WP
X$9 vss vdd \$9 wl_en pd[0][2] page \$17 pd[0][3] SP6TRowDecoderNand3X2
X$10 vss vdd \$3 wl_en pd[0][0] page \$10 pd[0][1] SP6TRowDecoderNand3X2
X$11 vss vdd \$19 wl_en pd[0][4] page \$23 pd[0][5] SP6TRowDecoderNand3X2
X$12 vss vdd \$24 wl_en pd[0][6] page \$31 pd[0][7] SP6TRowDecoderNand3X2
.ENDS SP6TRowDecoderDriverPage_2PD8R

.SUBCKT SP6TRowPredecoders_3_3B vss vdd pd[0][0] page[0] pd[0][1] pd[0][2]
+ page[1] pd[0][3] pd[0][4] page[2] pd[0][5] page[3] pd[0][6] pd[0][7] page[4]
+ page[5] page[6] page[7] clk a[0] a[1] a[2] a[3] a[4] a[5]
X$1 vss a[0] \$25 clk vdd SP6TDec_dff_x1
X$2 vss vdd \$19 \$25 SP6TDec_inv_x1
X$3 vdd vss \$19 \$20 \$21 pd[0][0] SP6TDec_and3_x1
X$4 vdd vss \$22 \$23 \$24 page[0] SP6TDec_and3_x1
X$5 vdd vss \$25 \$20 \$21 pd[0][1] SP6TDec_and3_x1
X$6 vss a[1] \$26 clk vdd SP6TDec_dff_x1
X$7 vdd vss \$19 \$26 \$21 pd[0][2] SP6TDec_and3_x1
X$8 vss vdd \$20 \$26 SP6TDec_inv_x1
X$9 vdd vss \$27 \$23 \$24 page[1] SP6TDec_and3_x1
X$10 vdd vss \$25 \$26 \$21 pd[0][3] SP6TDec_and3_x1
X$11 vss a[2] \$28 clk vdd SP6TDec_dff_x1
X$12 vdd vss \$19 \$20 \$28 pd[0][4] SP6TDec_and3_x1
X$13 vss vdd \$21 \$28 SP6TDec_inv_x1
X$14 vdd vss \$22 \$29 \$24 page[2] SP6TDec_and3_x1
X$15 vdd vss \$25 \$20 \$28 pd[0][5] SP6TDec_and3_x1
X$16 vss a[3] \$27 clk vdd SP6TDec_dff_x1
X$17 vdd vss \$27 \$29 \$24 page[3] SP6TDec_and3_x1
X$18 vss vdd \$22 \$27 SP6TDec_inv_x1
X$19 vdd vss \$19 \$26 \$28 pd[0][6] SP6TDec_and3_x1
X$20 vdd vss \$25 \$26 \$28 pd[0][7] SP6TDec_and3_x1
X$21 vss a[4] \$29 clk vdd SP6TDec_dff_x1
X$22 vdd vss \$22 \$23 \$30 page[4] SP6TDec_and3_x1
X$23 vss vdd \$23 \$29 SP6TDec_inv_x1
X$26 vss a[5] \$30 clk vdd SP6TDec_dff_x1
X$27 vdd vss \$27 \$23 \$30 page[5] SP6TDec_and3_x1
X$28 vss vdd \$24 \$30 SP6TDec_inv_x1
X$32 vdd vss \$22 \$29 \$30 page[6] SP6TDec_and3_x1
X$38 vdd vss \$27 \$29 \$30 page[7] SP6TDec_and3_x1
.ENDS SP6TRowPredecoders_3_3B

.SUBCKT SP6TArray_32X32 vss bl[0] bl_n[0] bl_n[1] bl[1] bl[2] bl_n[2] bl_n[3]
+ bl[3] bl[4] bl_n[4] bl_n[5] bl[5] bl[6] bl_n[6] bl_n[7] bl[7] bl[8] bl_n[8]
+ bl_n[9] bl[9] bl[10] bl_n[10] bl_n[11] bl[11] bl[12] bl_n[12] bl_n[13] bl[13]
+ bl[14] bl_n[14] bl_n[15] bl[15] wl[7] wl[8] wl[6] wl[9] wl[5] wl[10] wl[4]
+ wl[11] wl[3] wl[2] wl[1] wl[0] wl[12] wl[13] wl[14] wl[15] bl[16] bl_n[16]
+ bl_n[17] bl[17] bl[18] bl_n[18] bl_n[19] bl[19] bl[20] bl_n[20] bl_n[21]
+ bl[21] bl[22] bl_n[22] bl_n[23] bl[23] bl[24] bl_n[24] bl_n[25] bl[25] bl[26]
+ bl_n[26] bl_n[27] bl[27] bl[28] bl_n[28] bl_n[29] bl[29] bl[30] bl_n[30]
+ bl_n[31] bl[31] wl[31] wl[30] wl[29] wl[28] wl[27] wl[26] wl[25] vdd wl[16]
+ wl[24] wl[17] wl[18] wl[19] wl[20] wl[21] wl[22] wl[23]
X$1 vss vdd vss bl[0] vdd bl_n[0] bl_n[1] bl[1] bl[2] bl_n[2] bl_n[3] bl[3]
+ bl[4] bl_n[4] bl_n[5] bl[5] bl[6] bl_n[6] bl_n[7] bl[7] bl[8] bl_n[8] bl_n[9]
+ bl[9] bl[10] bl_n[10] bl_n[11] bl[11] bl[12] bl_n[12] bl_n[13] bl[13] bl[14]
+ bl_n[14] bl_n[15] bl[15] wl[7] wl[6] wl[5] wl[4] wl[3] wl[2] wl[1] wl[0]
+ bl[16] bl_n[16] bl_n[17] bl[17] bl[18] bl_n[18] bl_n[19] bl[19] bl[20]
+ bl_n[20] bl_n[21] bl[21] bl[22] bl_n[22] bl_n[23] bl[23] bl[24] bl_n[24]
+ bl_n[25] bl[25] bl[26] bl_n[26] bl_n[27] bl[27] bl[28] bl_n[28] bl_n[29]
+ bl[29] bl[30] bl_n[30] bl_n[31] bl[31] wl[11] wl[14] wl[8] wl[13] wl[9]
+ wl[12] wl[10] wl[15] SP6TArray_16X32
X$3 vss vdd vss bl[0] vdd bl_n[0] bl_n[1] bl[1] bl[2] bl_n[2] bl_n[3] bl[3]
+ bl[4] bl_n[4] bl_n[5] bl[5] bl[6] bl_n[6] bl_n[7] bl[7] bl[8] bl_n[8] bl_n[9]
+ bl[9] bl[10] bl_n[10] bl_n[11] bl[11] bl[12] bl_n[12] bl_n[13] bl[13] bl[14]
+ bl_n[14] bl_n[15] bl[15] wl[23] wl[22] wl[21] wl[20] wl[19] wl[18] wl[17]
+ wl[16] bl[16] bl_n[16] bl_n[17] bl[17] bl[18] bl_n[18] bl_n[19] bl[19] bl[20]
+ bl_n[20] bl_n[21] bl[21] bl[22] bl_n[22] bl_n[23] bl[23] bl[24] bl_n[24]
+ bl_n[25] bl[25] bl[26] bl_n[26] bl_n[27] bl[27] bl[28] bl_n[28] bl_n[29]
+ bl[29] bl[30] bl_n[30] bl_n[31] bl[31] wl[27] wl[30] wl[24] wl[29] wl[25]
+ wl[28] wl[26] wl[31] SP6TArray_16X32
.ENDS SP6TArray_32X32

.SUBCKT SP6TPrecharge precharge_n vdd bl bl_n \$6
M$1 vdd precharge_n bl \$6 sg13_lv_pmos L=0.13u W=0.5u AS=0.2675p AD=0.19p
+ PS=2.07u PD=1.26u
M$2 bl precharge_n bl_n \$6 sg13_lv_pmos L=0.13u W=0.5u AS=0.19p AD=0.19p
+ PS=1.26u PD=1.26u
M$3 bl_n precharge_n vdd \$6 sg13_lv_pmos L=0.13u W=0.5u AS=0.19p AD=0.2675p
+ PS=1.26u PD=2.07u
.ENDS SP6TPrecharge

.SUBCKT SP6TColMux_4C muxbl bl[0] bl_n[0] muxbl_n bl_n[1] bl[1] bl[2] bl_n[2]
+ bl_n[3] bl[3] mux[0] vss mux[1] mux[2] mux[3]
M$1 bl[3] mux[3] muxbl vss sg13_lv_nmos L=0.13u W=3.5u AS=1.19p AD=1.19p
+ PS=7.68u PD=7.68u
M$2 bl_n[2] mux[2] muxbl_n vss sg13_lv_nmos L=0.13u W=3.5u AS=1.19p AD=0.665p
+ PS=7.68u PD=3.88u
M$3 muxbl_n mux[3] bl_n[3] vss sg13_lv_nmos L=0.13u W=3.5u AS=0.665p AD=1.19p
+ PS=3.88u PD=7.68u
M$4 bl[1] mux[1] muxbl vss sg13_lv_nmos L=0.13u W=3.5u AS=1.19p AD=0.665p
+ PS=7.68u PD=3.88u
M$5 muxbl mux[2] bl[2] vss sg13_lv_nmos L=0.13u W=3.5u AS=0.665p AD=1.19p
+ PS=3.88u PD=7.68u
M$6 bl_n[0] mux[0] muxbl_n vss sg13_lv_nmos L=0.13u W=3.5u AS=1.19p AD=0.665p
+ PS=7.68u PD=3.88u
M$7 muxbl_n mux[1] bl_n[1] vss sg13_lv_nmos L=0.13u W=3.5u AS=0.665p AD=1.19p
+ PS=3.88u PD=7.68u
M$8 muxbl mux[0] bl[0] vss sg13_lv_nmos L=0.13u W=3.5u AS=1.19p AD=1.19p
+ PS=7.68u PD=7.68u
.ENDS SP6TColMux_4C

.SUBCKT SP6TReadWrite_4M bl vss bl_n vdd q d clk we_n
X$1 q vdd vss bl_n bl nsnrlatch_x1
X$2 vss vdd \$5 \$16 we_n nor2_x0
X$3 vss vdd \$16 \$11 inv_x0
X$4 vss d \$11 clk vdd dff_x1
X$5 vss vdd \$3 \$11 we_n nor2_x0
M$1 bl \$3 vss vss sg13_lv_nmos L=0.13u W=1.9u AS=0.5074p AD=0.361p PS=4.48u
+ PD=2.28u
M$2 vss \$5 bl_n vss sg13_lv_nmos L=0.13u W=1.9u AS=0.361p AD=0.5074p PS=2.28u
+ PD=4.48u
.ENDS SP6TReadWrite_4M

.SUBCKT SP6TClockWE clkup we we_en we_n vss vdd clkdown
X$1 vdd vss clkup clkdown buf_x2
X$2 vss we \$9 clkdown vdd dff_x1
X$3 vss vdd \$9 we_n we_en nand2_x0
.ENDS SP6TClockWE

.SUBCKT SP6TWLDrive_26LN100WN26LP200WP wl_drive vss wl_n vdd \$5 \$6
M$1 vss wl_n wl_drive \$5 sg13_lv_nmos L=0.13u W=1u AS=0.2775p AD=0.2775p
+ PS=2.61u PD=2.61u
M$3 vdd wl_n wl_drive \$6 sg13_lv_pmos L=0.13u W=2u AS=0.555p AD=0.555p
+ PS=4.11u PD=4.11u
.ENDS SP6TWLDrive_26LN100WN26LP200WP

.SUBCKT SP6TRowDecoderNand3X2 vss vdd wl_n[0] wl_en pd[0][0] page wl_n[1]
+ pd[0][1]
M$1 wl_n[0] wl_en \$12 vss sg13_lv_nmos L=0.13u W=0.49u AS=0.1666p AD=0.1078p
+ PS=1.66u PD=0.93u
M$2 \$12 pd[0][0] \$11 vss sg13_lv_nmos L=0.13u W=0.49u AS=0.1078p AD=0.1078p
+ PS=0.93u PD=0.93u
M$3 vss page \$11 vss sg13_lv_nmos L=0.13u W=0.49u AS=0.1708p AD=0.1078p
+ PS=1.35u PD=0.93u
M$4 vss page \$10 vss sg13_lv_nmos L=0.13u W=0.49u AS=0.1708p AD=0.1078p
+ PS=1.35u PD=0.93u
M$5 \$10 pd[0][1] \$9 vss sg13_lv_nmos L=0.13u W=0.49u AS=0.1078p AD=0.1078p
+ PS=0.93u PD=0.93u
M$6 \$9 wl_en wl_n[1] vss sg13_lv_nmos L=0.13u W=0.49u AS=0.1078p AD=0.1666p
+ PS=0.93u PD=1.66u
M$7 wl_n[0] wl_en vdd vdd sg13_lv_pmos L=0.13u W=0.49u AS=0.1666p AD=0.1708p
+ PS=1.66u PD=1.35u
M$8 vdd pd[0][0] wl_n[0] vdd sg13_lv_pmos L=0.13u W=0.49u AS=0.1708p AD=0.1078p
+ PS=1.35u PD=0.93u
M$9 wl_n[0] page vdd vdd sg13_lv_pmos L=0.13u W=0.49u AS=0.1078p AD=0.1708p
+ PS=0.93u PD=1.35u
M$10 vdd page wl_n[1] vdd sg13_lv_pmos L=0.13u W=0.49u AS=0.1708p AD=0.1078p
+ PS=1.35u PD=0.93u
M$11 wl_n[1] pd[0][1] vdd vdd sg13_lv_pmos L=0.13u W=0.49u AS=0.1078p
+ AD=0.1708p PS=0.93u PD=1.35u
M$12 vdd wl_en wl_n[1] vdd sg13_lv_pmos L=0.13u W=0.49u AS=0.1708p AD=0.1666p
+ PS=1.35u PD=1.66u
.ENDS SP6TRowDecoderNand3X2

.SUBCKT SP6TDec_and3_x1 vdd vss i0 i1 i2 q
M$1 \$1 i0 \$9 vss sg13_lv_nmos L=0.13u W=0.78u AS=0.2652p AD=0.1482p PS=2.24u
+ PD=1.16u
M$2 \$9 i1 \$8 vss sg13_lv_nmos L=0.13u W=0.78u AS=0.1482p AD=0.1482p PS=1.16u
+ PD=1.16u
M$3 \$8 i2 vss vss sg13_lv_nmos L=0.13u W=0.78u AS=0.1482p AD=0.5033p PS=1.16u
+ PD=3.21u
M$4 vss \$1 q vss sg13_lv_nmos L=0.13u W=2.8u AS=0.5033p AD=1.036p PS=3.21u
+ PD=6.34u
M$5 \$1 i0 vdd vdd sg13_lv_pmos L=0.13u W=1.2u AS=0.408p AD=0.228p PS=3.08u
+ PD=1.58u
M$6 vdd i1 \$1 vdd sg13_lv_pmos L=0.13u W=1.2u AS=0.228p AD=0.228p PS=1.58u
+ PD=1.58u
M$7 vdd i2 \$1 vdd sg13_lv_pmos L=0.13u W=1.2u AS=0.79p AD=0.228p PS=4.81u
+ PD=1.58u
M$8 vdd \$1 q vdd sg13_lv_pmos L=0.13u W=4.4u AS=0.79p AD=1.628p PS=4.81u
+ PD=9.54u
.ENDS SP6TDec_and3_x1

.SUBCKT SP6TDec_inv_x1 vss vdd nq i
M$1 vss i nq vss sg13_lv_nmos L=0.13u W=2.8u AS=0.952p AD=0.952p PS=6.28u
+ PD=6.28u
M$2 vdd i nq vdd sg13_lv_pmos L=0.13u W=4.4u AS=1.496p AD=1.496p PS=9.48u
+ PD=9.48u
.ENDS SP6TDec_inv_x1

.SUBCKT SP6TDec_dff_x1 vss i q clk vdd
M$1 \$4 i vss vss sg13_lv_nmos L=0.13u W=0.78u AS=0.2652p AD=0.1482p PS=2.24u
+ PD=1.16u
M$2 vss \$4 \$11 vss sg13_lv_nmos L=0.13u W=0.78u AS=0.1482p AD=0.1482p
+ PS=1.16u PD=1.16u
M$3 \$11 \$2 \$6 vss sg13_lv_nmos L=0.13u W=0.78u AS=0.1482p AD=0.1482p
+ PS=1.16u PD=1.16u
M$4 \$6 \$3 \$12 vss sg13_lv_nmos L=0.13u W=0.78u AS=0.1482p AD=0.1482p
+ PS=1.16u PD=1.16u
M$5 \$12 \$7 vss vss sg13_lv_nmos L=0.13u W=0.78u AS=0.1482p AD=0.1638p
+ PS=1.16u PD=1.2u
M$6 vss \$6 \$7 vss sg13_lv_nmos L=0.13u W=0.78u AS=0.1638p AD=0.2496p PS=1.2u
+ PD=1.42u
M$7 \$7 \$3 \$8 vss sg13_lv_nmos L=0.13u W=0.78u AS=0.2496p AD=0.1482p PS=1.42u
+ PD=1.16u
M$8 \$8 \$2 \$10 vss sg13_lv_nmos L=0.13u W=0.78u AS=0.1482p AD=0.1482p
+ PS=1.16u PD=1.16u
M$9 \$10 q vss vss sg13_lv_nmos L=0.13u W=0.78u AS=0.1482p AD=0.7217p PS=1.16u
+ PD=2.88u
M$10 vss \$8 q vss sg13_lv_nmos L=0.13u W=2.17u AS=0.7217p AD=0.7378p PS=2.88u
+ PD=5.02u
M$11 \$2 clk vss vss sg13_lv_nmos L=0.13u W=0.78u AS=0.2652p AD=0.1716p
+ PS=2.24u PD=1.22u
M$12 vss \$2 \$3 vss sg13_lv_nmos L=0.13u W=0.78u AS=0.1716p AD=0.2652p
+ PS=1.22u PD=2.24u
M$13 \$2 clk vdd vdd sg13_lv_pmos L=0.13u W=1.2u AS=0.408p AD=0.264p PS=3.08u
+ PD=1.64u
M$14 vdd \$2 \$3 vdd sg13_lv_pmos L=0.13u W=1.2u AS=0.264p AD=0.408p PS=1.64u
+ PD=3.08u
M$15 \$4 i vdd vdd sg13_lv_pmos L=0.13u W=1.2u AS=0.408p AD=0.228p PS=3.08u
+ PD=1.58u
M$16 vdd \$4 \$15 vdd sg13_lv_pmos L=0.13u W=1.2u AS=0.228p AD=0.228p PS=1.58u
+ PD=1.58u
M$17 \$15 \$3 \$6 vdd sg13_lv_pmos L=0.13u W=1.2u AS=0.228p AD=0.228p PS=1.58u
+ PD=1.58u
M$18 \$6 \$2 \$16 vdd sg13_lv_pmos L=0.13u W=1.2u AS=0.228p AD=0.228p PS=1.58u
+ PD=1.58u
M$19 \$16 \$7 vdd vdd sg13_lv_pmos L=0.13u W=1.2u AS=0.228p AD=0.252p PS=1.58u
+ PD=1.62u
M$20 vdd \$6 \$7 vdd sg13_lv_pmos L=0.13u W=1.2u AS=0.252p AD=0.384p PS=1.62u
+ PD=1.84u
M$21 \$7 \$2 \$8 vdd sg13_lv_pmos L=0.13u W=1.2u AS=0.384p AD=0.228p PS=1.84u
+ PD=1.58u
M$22 \$8 \$3 \$17 vdd sg13_lv_pmos L=0.13u W=1.2u AS=0.228p AD=0.228p PS=1.58u
+ PD=1.58u
M$23 vdd q \$17 vdd sg13_lv_pmos L=0.13u W=1.2u AS=1.2484p AD=0.228p PS=4.48u
+ PD=1.58u
M$24 vdd \$8 q vdd sg13_lv_pmos L=0.13u W=3.77u AS=1.2484p AD=1.2818p PS=4.48u
+ PD=8.22u
.ENDS SP6TDec_dff_x1

.SUBCKT SP6TArray_16X32 \$1 nwell vss bl[0] vdd bl_n[0] bl_n[1] bl[1] bl[2]
+ bl_n[2] bl_n[3] bl[3] bl[4] bl_n[4] bl_n[5] bl[5] bl[6] bl_n[6] bl_n[7] bl[7]
+ bl[8] bl_n[8] bl_n[9] bl[9] bl[10] bl_n[10] bl_n[11] bl[11] bl[12] bl_n[12]
+ bl_n[13] bl[13] bl[14] bl_n[14] bl_n[15] bl[15] wl[7] wl[6] wl[5] wl[4] wl[3]
+ wl[2] wl[1] wl[0] bl[16] bl_n[16] bl_n[17] bl[17] bl[18] bl_n[18] bl_n[19]
+ bl[19] bl[20] bl_n[20] bl_n[21] bl[21] bl[22] bl_n[22] bl_n[23] bl[23] bl[24]
+ bl_n[24] bl_n[25] bl[25] bl[26] bl_n[26] bl_n[27] bl[27] bl[28] bl_n[28]
+ bl_n[29] bl[29] bl[30] bl_n[30] bl_n[31] bl[31] wl[11] wl[14] wl[8] wl[13]
+ wl[9] wl[12] wl[10] wl[15]
X$1 \$1 nwell vss bl[16] vdd bl_n[16] bl_n[17] bl[17] bl[18] bl_n[18] bl_n[19]
+ bl[19] bl[20] bl_n[20] bl_n[21] bl[21] bl[22] bl_n[22] bl_n[23] bl[23] wl[5]
+ wl[6] wl[4] wl[2] wl[3] wl[1] wl[7] wl[0] bl[24] bl_n[24] bl_n[25] bl[25]
+ bl[26] bl_n[26] bl_n[27] bl[27] bl[28] bl_n[28] bl_n[29] bl[29] bl[30]
+ bl_n[30] bl_n[31] bl[31] wl[15] wl[8] wl[9] wl[10] wl[11] wl[12] wl[13]
+ wl[14] SP6TArray_16X16
X$2 \$1 nwell vss bl[0] vdd bl_n[0] bl_n[1] bl[1] bl[2] bl_n[2] bl_n[3] bl[3]
+ bl[4] bl_n[4] bl_n[5] bl[5] bl[6] bl_n[6] bl_n[7] bl[7] wl[5] wl[6] wl[4]
+ wl[2] wl[3] wl[1] wl[7] wl[0] bl[8] bl_n[8] bl_n[9] bl[9] bl[10] bl_n[10]
+ bl_n[11] bl[11] bl[12] bl_n[12] bl_n[13] bl[13] bl[14] bl_n[14] bl_n[15]
+ bl[15] wl[15] wl[8] wl[9] wl[10] wl[11] wl[12] wl[13] wl[14] SP6TArray_16X16
.ENDS SP6TArray_16X32

.SUBCKT nor2_x0 vss vdd nq i0 i1
M$1 vss i0 nq vss sg13_lv_nmos L=0.13u W=0.78u AS=0.2652p AD=0.1482p PS=2.24u
+ PD=1.16u
M$2 nq i1 vss vss sg13_lv_nmos L=0.13u W=0.78u AS=0.1482p AD=0.2808p PS=1.16u
+ PD=2.28u
M$3 vdd i0 \$6 vdd sg13_lv_pmos L=0.13u W=0.78u AS=0.2652p AD=0.1482p PS=2.24u
+ PD=1.16u
M$4 \$6 i1 nq vdd sg13_lv_pmos L=0.13u W=0.78u AS=0.1482p AD=0.2808p PS=1.16u
+ PD=2.28u
.ENDS nor2_x0

.SUBCKT nsnrlatch_x1 q vdd vss nset nrst
M$1 q nset \$8 vss sg13_lv_nmos L=0.13u W=1.31u AS=0.4454p AD=0.2489p PS=3.3u
+ PD=1.69u
M$2 \$8 nq vss vss sg13_lv_nmos L=0.13u W=1.31u AS=0.2489p AD=0.2489p PS=1.69u
+ PD=1.69u
M$3 vss q \$7 vss sg13_lv_nmos L=0.13u W=1.31u AS=0.2489p AD=0.262p PS=1.69u
+ PD=1.71u
M$4 \$7 nrst nq vss sg13_lv_nmos L=0.13u W=1.31u AS=0.262p AD=0.4454p PS=1.71u
+ PD=3.3u
M$5 vdd nset q vdd sg13_lv_pmos L=0.13u W=1.3u AS=0.442p AD=0.247p PS=3.28u
+ PD=1.68u
M$6 q nq vdd vdd sg13_lv_pmos L=0.13u W=1.3u AS=0.247p AD=0.247p PS=1.68u
+ PD=1.68u
M$7 vdd q nq vdd sg13_lv_pmos L=0.13u W=1.3u AS=0.247p AD=0.26p PS=1.68u PD=1.7u
M$8 nq nrst vdd vdd sg13_lv_pmos L=0.13u W=1.3u AS=0.26p AD=0.442p PS=1.7u
+ PD=3.28u
.ENDS nsnrlatch_x1

.SUBCKT dff_x1 vss i q clk vdd
M$1 \$4 i vss vss sg13_lv_nmos L=0.13u W=0.78u AS=0.2652p AD=0.1482p PS=2.24u
+ PD=1.16u
M$2 vss \$4 \$12 vss sg13_lv_nmos L=0.13u W=0.78u AS=0.1482p AD=0.1482p
+ PS=1.16u PD=1.16u
M$3 \$12 \$2 \$6 vss sg13_lv_nmos L=0.13u W=0.78u AS=0.1482p AD=0.1482p
+ PS=1.16u PD=1.16u
M$4 \$6 \$3 \$11 vss sg13_lv_nmos L=0.13u W=0.78u AS=0.1482p AD=0.1482p
+ PS=1.16u PD=1.16u
M$5 \$11 \$7 vss vss sg13_lv_nmos L=0.13u W=0.78u AS=0.1482p AD=0.1482p
+ PS=1.16u PD=1.16u
M$6 vss \$6 \$7 vss sg13_lv_nmos L=0.13u W=0.78u AS=0.1482p AD=0.2028p PS=1.16u
+ PD=1.3u
M$7 \$7 \$3 \$8 vss sg13_lv_nmos L=0.13u W=0.78u AS=0.2028p AD=0.1482p PS=1.3u
+ PD=1.16u
M$8 \$8 \$2 \$10 vss sg13_lv_nmos L=0.13u W=0.78u AS=0.1482p AD=0.1482p
+ PS=1.16u PD=1.16u
M$9 \$10 q vss vss sg13_lv_nmos L=0.13u W=0.78u AS=0.1482p AD=0.2265p PS=1.16u
+ PD=1.38u
M$10 vss \$8 q vss sg13_lv_nmos L=0.13u W=0.83u AS=0.2265p AD=0.2822p PS=1.38u
+ PD=2.34u
M$11 \$2 clk vss vss sg13_lv_nmos L=0.13u W=0.78u AS=0.2652p AD=0.156p PS=2.24u
+ PD=1.18u
M$12 vss \$2 \$3 vss sg13_lv_nmos L=0.13u W=0.78u AS=0.156p AD=0.2652p PS=1.18u
+ PD=2.24u
M$13 \$2 clk vdd vdd sg13_lv_pmos L=0.13u W=0.78u AS=0.2652p AD=0.156p PS=2.24u
+ PD=1.18u
M$14 vdd \$2 \$3 vdd sg13_lv_pmos L=0.13u W=0.78u AS=0.156p AD=0.2652p PS=1.18u
+ PD=2.24u
M$15 \$4 i vdd vdd sg13_lv_pmos L=0.13u W=0.78u AS=0.2652p AD=0.1482p PS=2.24u
+ PD=1.16u
M$16 vdd \$4 \$15 vdd sg13_lv_pmos L=0.13u W=0.78u AS=0.1482p AD=0.1482p
+ PS=1.16u PD=1.16u
M$17 \$15 \$3 \$6 vdd sg13_lv_pmos L=0.13u W=0.78u AS=0.1482p AD=0.1482p
+ PS=1.16u PD=1.16u
M$18 \$6 \$2 \$16 vdd sg13_lv_pmos L=0.13u W=0.78u AS=0.1482p AD=0.1482p
+ PS=1.16u PD=1.16u
M$19 \$16 \$7 vdd vdd sg13_lv_pmos L=0.13u W=0.78u AS=0.1482p AD=0.1482p
+ PS=1.16u PD=1.16u
M$20 vdd \$6 \$7 vdd sg13_lv_pmos L=0.13u W=0.78u AS=0.1482p AD=0.2028p
+ PS=1.16u PD=1.3u
M$21 \$7 \$2 \$8 vdd sg13_lv_pmos L=0.13u W=0.78u AS=0.2028p AD=0.1482p PS=1.3u
+ PD=1.16u
M$22 \$8 \$3 \$17 vdd sg13_lv_pmos L=0.13u W=0.78u AS=0.1482p AD=0.1482p
+ PS=1.16u PD=1.16u
M$23 vdd q \$17 vdd sg13_lv_pmos L=0.13u W=0.78u AS=0.2241p AD=0.1482p PS=1.37u
+ PD=1.16u
M$24 vdd \$8 q vdd sg13_lv_pmos L=0.13u W=0.82u AS=0.2241p AD=0.2788p PS=1.37u
+ PD=2.32u
.ENDS dff_x1

.SUBCKT buf_x2 vdd vss i q
M$1 \$1 i vss vss sg13_lv_nmos L=0.13u W=0.78u AS=0.2652p AD=0.2092p PS=2.24u
+ PD=1.48u
M$2 vss \$1 q vss sg13_lv_nmos L=0.13u W=2.14u AS=0.4125p AD=0.5671p PS=2.93u
+ PD=4.27u
M$4 vdd i \$1 vdd sg13_lv_pmos L=0.13u W=0.78u AS=0.2075p AD=0.2652p PS=1.47u
+ PD=2.24u
M$5 vdd \$1 q vdd sg13_lv_pmos L=0.13u W=2.12u AS=0.4089p AD=0.5618p PS=2.91u
+ PD=4.24u
.ENDS buf_x2

.SUBCKT nand2_x0 vss vdd i0 nq i1
M$1 vss i0 \$6 vss sg13_lv_nmos L=0.13u W=0.78u AS=0.2652p AD=0.1482p PS=2.24u
+ PD=1.16u
M$2 \$6 i1 nq vss sg13_lv_nmos L=0.13u W=0.78u AS=0.1482p AD=0.2808p PS=1.16u
+ PD=2.28u
M$3 vdd i0 nq vdd sg13_lv_pmos L=0.13u W=0.78u AS=0.2652p AD=0.1482p PS=2.24u
+ PD=1.16u
M$4 nq i1 vdd vdd sg13_lv_pmos L=0.13u W=0.78u AS=0.1482p AD=0.2808p PS=1.16u
+ PD=2.28u
.ENDS nand2_x0

.SUBCKT inv_x0 vss vdd nq i
M$1 vss i nq vss sg13_lv_nmos L=0.13u W=0.78u AS=0.2652p AD=0.2652p PS=2.24u
+ PD=2.24u
M$2 vdd i nq vdd sg13_lv_pmos L=0.13u W=0.78u AS=0.2652p AD=0.2652p PS=2.24u
+ PD=2.24u
.ENDS inv_x0

.SUBCKT SP6TArray_16X16 \$1 nwell vss bl[0] vdd bl_n[0] bl_n[1] bl[1] bl[2]
+ bl_n[2] bl_n[3] bl[3] bl[4] bl_n[4] bl_n[5] bl[5] bl[6] bl_n[6] bl_n[7] bl[7]
+ wl[5] wl[6] wl[4] wl[2] wl[3] wl[1] wl[7] wl[0] bl[8] bl_n[8] bl_n[9] bl[9]
+ bl[10] bl_n[10] bl_n[11] bl[11] bl[12] bl_n[12] bl_n[13] bl[13] bl[14]
+ bl_n[14] bl_n[15] bl[15] wl[15] wl[8] wl[9] wl[10] wl[11] wl[12] wl[13] wl[14]
X$1 \$1 vss bl[8] vdd bl_n[8] bl_n[9] bl[9] bl[10] bl_n[10] bl_n[11] bl[11]
+ wl[7] wl[6] wl[5] wl[4] wl[2] wl[1] wl[0] wl[3] bl[12] bl_n[12] bl_n[13]
+ bl[13] bl[14] bl_n[14] bl_n[15] bl[15] wl[15] wl[8] wl[9] wl[10] wl[11]
+ wl[12] wl[13] wl[14] nwell SP6TArray_16X8
X$2 \$1 vss bl[0] vdd bl_n[0] bl_n[1] bl[1] bl[2] bl_n[2] bl_n[3] bl[3] wl[7]
+ wl[6] wl[5] wl[4] wl[2] wl[1] wl[0] wl[3] bl[4] bl_n[4] bl_n[5] bl[5] bl[6]
+ bl_n[6] bl_n[7] bl[7] wl[15] wl[8] wl[9] wl[10] wl[11] wl[12] wl[13] wl[14]
+ nwell SP6TArray_16X8
.ENDS SP6TArray_16X16

.SUBCKT SP6TArray_16X8 \$1 vss bl[0] vdd bl_n[0] bl_n[1] bl[1] bl[2] bl_n[2]
+ bl_n[3] bl[3] wl[7] wl[6] wl[5] wl[4] wl[2] wl[1] wl[0] wl[3] bl[4] bl_n[4]
+ bl_n[5] bl[5] bl[6] bl_n[6] bl_n[7] bl[7] wl[15] wl[8] wl[9] wl[10] wl[11]
+ wl[12] wl[13] wl[14] \$I2
X$1 \$1 \$I2 wl[8] vss bl[0] vdd bl_n[0] bl_n[1] bl[1] bl[2] bl_n[2] bl_n[3]
+ bl[3] wl[10] wl[11] wl[9] bl[4] bl_n[4] bl_n[5] bl[5] bl[6] bl_n[6] bl_n[7]
+ bl[7] wl[14] wl[13] wl[12] wl[15] SP6TArray_8X8
X$2 \$1 \$I2 wl[0] vss bl[0] vdd bl_n[0] bl_n[1] bl[1] bl[2] bl_n[2] bl_n[3]
+ bl[3] wl[2] wl[3] wl[1] bl[4] bl_n[4] bl_n[5] bl[5] bl[6] bl_n[6] bl_n[7]
+ bl[7] wl[6] wl[5] wl[4] wl[7] SP6TArray_8X8
.ENDS SP6TArray_16X8

.SUBCKT SP6TArray_8X8 \$1 nwell wl[0] vss bl[0] vdd bl_n[0] bl_n[1] bl[1] bl[2]
+ bl_n[2] bl_n[3] bl[3] wl[2] wl[3] wl[1] bl[4] bl_n[4] bl_n[5] bl[5] bl[6]
+ bl_n[6] bl_n[7] bl[7] wl[6] wl[5] wl[4] wl[7]
X$1 vss vdd bl[4] bl_n[4] bl[5] bl_n[5] bl[6] bl_n[6] bl[7] bl_n[7] wl[0] wl[1]
+ wl[2] wl[3] wl[4] wl[5] wl[6] wl[7] \$1 nwell SP6TArray_8X4
X$2 vss vdd bl[0] bl_n[0] bl[1] bl_n[1] bl[2] bl_n[2] bl[3] bl_n[3] wl[0] wl[1]
+ wl[2] wl[3] wl[4] wl[5] wl[6] wl[7] \$1 nwell SP6TArray_8X4
.ENDS SP6TArray_8X8

.SUBCKT SP6TArray_8X4 vss vdd bl[0] bl_n[0] bl[1] bl_n[1] bl[2] bl_n[2] bl[3]
+ bl_n[3] wl[0] wl[1] wl[2] wl[3] wl[4] wl[5] wl[6] wl[7] \$29 \$I19
X$1 vss vdd bl[0] bl_n[0] bl[1] bl_n[1] bl[2] bl_n[2] bl[3] bl_n[3] wl[4] wl[5]
+ wl[6] wl[7] \$29 \$I19 SP6TArray_4X4
X$2 vss vdd bl[0] bl_n[0] bl[1] bl_n[1] bl[2] bl_n[2] bl[3] bl_n[3] wl[0] wl[1]
+ wl[2] wl[3] \$29 \$I19 SP6TArray_4X4
.ENDS SP6TArray_8X4

.SUBCKT SP6TArray_4X4 vss vdd bl[0] bl_n[0] bl[1] bl_n[1] bl[2] bl_n[2] bl[3]
+ bl_n[3] wl[0] wl[1] wl[2] wl[3] \$25 nwell
X$1 vss vdd bl[0] bl_n[0] bl[1] bl_n[1] wl[0] wl[1] wl[2] wl[3] \$25 nwell
+ SP6TArray_4X2
X$2 vss vdd bl[2] bl_n[2] bl[3] bl_n[3] wl[0] wl[1] wl[2] wl[3] \$25 nwell
+ SP6TArray_4X2
.ENDS SP6TArray_4X4

.SUBCKT SP6TArray_4X2 vss vdd bl[0] bl_n[0] bl[1] bl_n[1] wl[0] wl[1] wl[2]
+ wl[3] \$15 \$I11
X$1 vss vdd bl[0] bl_n[0] bl[1] bl_n[1] wl[2] wl[3] \$15 \$I11 SP6TArray_2X2
X$2 vss vdd bl[0] bl_n[0] bl[1] bl_n[1] wl[0] wl[1] \$15 \$I11 SP6TArray_2X2
.ENDS SP6TArray_4X2

.SUBCKT SP6TArray_2X2 vss vdd bl[0] bl_n[0] bl[1] bl_n[1] wl[0] wl[1] \$13 nwell
X$1 vss vdd bl[1] bl_n[1] wl[0] wl[1] \$13 nwell SP6TArray_2X1
X$2 vss vdd bl[0] bl_n[0] wl[0] wl[1] \$13 nwell SP6TArray_2X1
.ENDS SP6TArray_2X2

.SUBCKT SP6TArray_2X1 vss vdd bl[0] bl_n[0] wl[0] wl[1] \$8 \$I7
X$1 vss bl[0] wl[1] vdd bl_n[0] \$8 \$I7 SP6TCell
X$2 vss bl[0] wl[0] vdd bl_n[0] \$8 \$I7 SP6TCell
.ENDS SP6TArray_2X1

.SUBCKT SP6TCell vss bl wl vdd bl_n \$9 \$10
M$1 vss \$1 \$6 \$9 sg13_lv_nmos L=0.13u W=0.2u AS=0.068p AD=0.043p PS=1.08u
+ PD=0.63u
M$2 \$6 wl bl_n \$9 sg13_lv_nmos L=0.13u W=0.2u AS=0.043p AD=0.068p PS=0.63u
+ PD=1.08u
M$3 bl wl \$1 \$9 sg13_lv_nmos L=0.13u W=0.2u AS=0.068p AD=0.043p PS=1.08u
+ PD=0.63u
M$4 \$1 \$6 vss \$9 sg13_lv_nmos L=0.13u W=0.2u AS=0.043p AD=0.068p PS=0.63u
+ PD=1.08u
M$5 \$1 \$6 vdd \$10 sg13_lv_pmos L=0.13u W=0.15u AS=0.09075p AD=0.0705p
+ PS=1.41u PD=1.14u
M$6 vdd \$1 \$6 \$10 sg13_lv_pmos L=0.13u W=0.15u AS=0.0705p AD=0.09075p
+ PS=1.14u PD=1.41u
.ENDS SP6TCell
