* testlib

* Device subcircuits
*
.subckt rsil n1 n2 l=1e-6 w=1e-6
.param rsil_res={l*7.0/w}
Rres n1 n2 r={rsil_res} rsil l=l w=w
.ends rsil

.subckt rppd n1 n2 l=1e-6 w=1e-6
.param rppd_res={l*260.0/w}
Rres n1 n2 r={rppd_res} rppd l=l w=w
.ends rppd

.subckt dantenna an cat params: w=0.48e-6 l=0.48e-6
Ddio an cat dantenna a=(w*l) p=(2*(w + l))
.ends dantenna

.subckt dpantenna an cat params: w=0.48e-6 l=0.48e-6
Ddio an cat dpantenna a=(w*l) p=(2*(w + l))
.ends dpantenna

.subckt sg13_lv_nmos s g d b params: l=0.13e-6 w=0.15e-6
Mtrans s g d b sg13_lv_nmos l=l w=w
.ends sg13_lv_nmos

.subckt sg13_lv_pmos s g d b params: l=0.13e-6 w=0.15e-6
Mtrans s g d b sg13_lv_pmos l=l w=w
.ends sg13_lv_pmos

.subckt sg13_hv_nmos s g d b params: l=0.45e-6 w=0.3e-6
Mtrans s g d b sg13_hv_nmos l=l w=w
.ends sg13_hv_nmos

.subckt sg13_hv_pmos s g d b params: l=0.45e-6 w=0.3e-6
Mtrans s g d b sg13_hv_pmos l=l w=w
.ends sg13_hv_pmos

* Library cells
*
.subckt BondPad PAD
.ends BondPad

.subckt inv_x0 vdd vss i nq
Xnmos vss i nq vss sg13_lv_nmos l=1.3e-07 w=7.8e-07
Xpmos vdd i nq vdd sg13_lv_pmos l=1.3e-07 w=7.8e-07
.ends inv_x0

.subckt nand2_x0 vdd vss nq i0 i1
Xi0_nmos vss i0 _net0 vss sg13_lv_nmos l=1.3e-07 w=7.8e-07
Xi0_pmos vdd i0 nq vdd sg13_lv_pmos l=1.3e-07 w=7.8e-07
Xi1_nmos _net0 i1 nq vss sg13_lv_nmos l=1.3e-07 w=7.8e-07
Xi1_pmos nq i1 vdd vdd sg13_lv_pmos l=1.3e-07 w=7.8e-07
.ends nand2_x0

.subckt SP6TNonOverlapClock_8S1R vss vdd clk firststage[0] firststage[1] firststage[2] firststage[3] firststage[4] firststage[5] firststage[6] firststage[7] firststage[8] secondstage[0] secondstage[1] secondstage[2] secondstage[3] secondstage[4] secondstage[5] secondstage[6] secondstage[7] secondstage[8]
Xclkinv vdd vss clk clk_n inv_x0
Xfirstnand2 vdd vss firststage[0] clk secondstage[8] nand2_x0
Xfirststage[0] vdd vss firststage[0] firststage[1] inv_x0
Xfirststage[1] vdd vss firststage[1] firststage[2] inv_x0
Xfirststage[2] vdd vss firststage[2] firststage[3] inv_x0
Xfirststage[3] vdd vss firststage[3] firststage[4] inv_x0
Xfirststage[4] vdd vss firststage[4] firststage[5] inv_x0
Xfirststage[5] vdd vss firststage[5] firststage[6] inv_x0
Xfirststage[6] vdd vss firststage[6] firststage[7] inv_x0
Xfirststage[7] vdd vss firststage[7] firststage[8] inv_x0
Xsecondnand2 vdd vss secondstage[0] clk_n firststage[8] nand2_x0
Xsecondstage[0] vdd vss secondstage[0] secondstage[1] inv_x0
Xsecondstage[1] vdd vss secondstage[1] secondstage[2] inv_x0
Xsecondstage[2] vdd vss secondstage[2] secondstage[3] inv_x0
Xsecondstage[3] vdd vss secondstage[3] secondstage[4] inv_x0
Xsecondstage[4] vdd vss secondstage[4] secondstage[5] inv_x0
Xsecondstage[5] vdd vss secondstage[5] secondstage[6] inv_x0
Xsecondstage[6] vdd vss secondstage[6] secondstage[7] inv_x0
Xsecondstage[7] vdd vss secondstage[7] secondstage[8] inv_x0
.ends SP6TNonOverlapClock_8S1R

.subckt buf_x1 vdd vss i q
Xstage0_nmos _i_n i vss vss sg13_lv_nmos l=1.3e-07 w=7.8e-07
Xstage0_pmos _i_n i vdd vdd sg13_lv_pmos l=1.3e-07 w=7.8e-07
Xnmos vss _i_n q vss sg13_lv_nmos l=1.3e-07 w=1.07e-06
Xpmos vdd _i_n q vdd sg13_lv_pmos l=1.3e-07 w=1.06e-06
.ends buf_x1

.subckt inv_x1 vdd vss i nq
Xnmos vss i nq vss sg13_lv_nmos l=1.3e-07 w=1.46e-06
Xpmos vdd i nq vdd sg13_lv_pmos l=1.3e-07 w=1.45e-06
.ends inv_x1

.subckt SP6TClockGenerator_8S1R vss vdd clk decodeclk columnclk precharge_n wl_en we_en
Xnonovl vss vdd clk firststage[0] firststage[1] firststage[2] firststage[3] firststage[4] firststage[5] firststage[6] firstpulse firststage[8] secondstage[0] secondstage[1] secondstage[2] secondstage[3] secondstage[4] secondstage[5] secondstage[6] secondpulse secondstage[8] SP6TNonOverlapClock_8S1R
Xdecodeclkbuf vdd vss clk decodeclk buf_x1
Xprechargeinv vdd vss secondpulse precharge_n inv_x1
Xwlenbuf vdd vss firstpulse wl_en buf_x1
Xcolumnclkbuf vdd vss clk columnclk buf_x1
Xweenbuf vdd vss firstpulse we_en buf_x1
.ends SP6TClockGenerator_8S1R

.subckt SP6TDec_dff_x1 vdd vss i clk q
Xclk_nmos _clk_n clk vss vss sg13_lv_nmos l=1.3e-07 w=7.8e-07
Xclk_pmos _clk_n clk vdd vdd sg13_lv_pmos l=1.3e-07 w=1.2e-06
Xclk_n_nmos0 vss _clk_n _clk_buf vss sg13_lv_nmos l=1.3e-07 w=7.8e-07
Xclk_n_pmos0 vdd _clk_n _clk_buf vdd sg13_lv_pmos l=1.3e-07 w=1.2e-06
Xi_nmos _u i vss vss sg13_lv_nmos l=1.3e-07 w=7.8e-07
Xi_pmos _u i vdd vdd sg13_lv_pmos l=1.3e-07 w=1.2e-06
Xu_nmos vss _u _net0 vss sg13_lv_nmos l=1.3e-07 w=7.8e-07
Xu_pmos vdd _u _net1 vdd sg13_lv_pmos l=1.3e-07 w=1.2e-06
Xclk_n_nmos1 _net0 _clk_n _dff_m vss sg13_lv_nmos l=1.3e-07 w=7.8e-07
Xclk_buf_pmos0 _net1 _clk_buf _dff_m vdd sg13_lv_pmos l=1.3e-07 w=1.2e-06
Xclk_buf_nmos0 _dff_m _clk_buf _net2 vss sg13_lv_nmos l=1.3e-07 w=7.8e-07
Xclk_n_pmos1 _dff_m _clk_n _net3 vdd sg13_lv_pmos l=1.3e-07 w=1.2e-06
Xy_nmos _net2 _y vss vss sg13_lv_nmos l=1.3e-07 w=7.8e-07
Xy_pmos _net3 _y vdd vdd sg13_lv_pmos l=1.3e-07 w=1.2e-06
Xdff_m_nmos vss _dff_m _y vss sg13_lv_nmos l=1.3e-07 w=7.8e-07
Xdff_m_pmos vdd _dff_m _y vdd sg13_lv_pmos l=1.3e-07 w=1.2e-06
Xclk_buf_nmos1 _y _clk_buf _dff_s vss sg13_lv_nmos l=1.3e-07 w=7.8e-07
Xclk_n_pmos2 _y _clk_n _dff_s vdd sg13_lv_pmos l=1.3e-07 w=1.2e-06
Xclk_n_nmos2 _dff_s _clk_n _net4 vss sg13_lv_nmos l=1.3e-07 w=7.8e-07
Xclk_buf_pmos1 _dff_s _clk_buf _net5 vdd sg13_lv_pmos l=1.3e-07 w=1.2e-06
Xq_nmos _net4 q vss vss sg13_lv_nmos l=1.3e-07 w=7.8e-07
Xq_pmos _net5 q vdd vdd sg13_lv_pmos l=1.3e-07 w=1.2e-06
Xdff_s_nmos vss _dff_s q vss sg13_lv_nmos l=1.3e-07 w=2.17e-06
Xdff_s_pmos vdd _dff_s q vdd sg13_lv_pmos l=1.3e-07 w=3.77e-06
.ends SP6TDec_dff_x1

.subckt SP6TDec_inv_x1 vdd vss i nq
Xnmos vss i nq vss sg13_lv_nmos l=1.3e-07 w=2.8e-06
Xpmos vdd i nq vdd sg13_lv_pmos l=1.3e-07 w=4.4e-06
.ends SP6TDec_inv_x1

.subckt SP6TDec_nand2_x0 vdd vss nq i0 i1
Xi0_nmos vss i0 _net0 vss sg13_lv_nmos l=1.3e-07 w=7.8e-07
Xi0_pmos vdd i0 nq vdd sg13_lv_pmos l=1.3e-07 w=1.2e-06
Xi1_nmos _net0 i1 nq vss sg13_lv_nmos l=1.3e-07 w=7.8e-07
Xi1_pmos nq i1 vdd vdd sg13_lv_pmos l=1.3e-07 w=1.2e-06
.ends SP6TDec_nand2_x0

.subckt SP6TDec_inv_x2 vdd vss i nq
Xnmos[0] vss i nq vss sg13_lv_nmos l=1.3e-07 w=2.8e-06
Xpmos[0] vdd i nq vdd sg13_lv_pmos l=1.3e-07 w=4.4e-06
Xnmos[1] nq i vss vss sg13_lv_nmos l=1.3e-07 w=2.8e-06
Xpmos[1] nq i vdd vdd sg13_lv_pmos l=1.3e-07 w=4.4e-06
.ends SP6TDec_inv_x2

.subckt SP6TLatchedDecoder_2A2R vss vdd clk a[0] a[1] line[0] line[1] line[2] line[3]
Xaff[0] vdd vss a[0] clk aint[0] SP6TDec_dff_x1
Xaff[1] vdd vss a[1] clk aint[1] SP6TDec_dff_x1
Xainv[0] vdd vss aint[0] aint_n[0] SP6TDec_inv_x1
Xainv[1] vdd vss aint[1] aint_n[1] SP6TDec_inv_x1
Xlinenand[0] vdd vss line_n[0] aint_n[0] aint_n[1] SP6TDec_nand2_x0
Xlinenand[1] vdd vss line_n[1] aint[0] aint_n[1] SP6TDec_nand2_x0
Xlinenand[2] vdd vss line_n[2] aint_n[0] aint[1] SP6TDec_nand2_x0
Xlinenand[3] vdd vss line_n[3] aint[0] aint[1] SP6TDec_nand2_x0
Xlineinv[0] vdd vss line_n[0] line[0] SP6TDec_inv_x2
Xlineinv[1] vdd vss line_n[1] line[1] SP6TDec_inv_x2
Xlineinv[2] vdd vss line_n[2] line[2] SP6TDec_inv_x2
Xlineinv[3] vdd vss line_n[3] line[3] SP6TDec_inv_x2
.ends SP6TLatchedDecoder_2A2R

.subckt SP6TDec_and3_x1 vdd vss q i0 i1 i2
Xi0_nmos nq i0 _net0 vss sg13_lv_nmos l=1.3e-07 w=7.8e-07
Xi0_pmos nq i0 vdd vdd sg13_lv_pmos l=1.3e-07 w=1.2e-06
Xi1_nmos _net0 i1 _net1 vss sg13_lv_nmos l=1.3e-07 w=7.8e-07
Xi1_pmos vdd i1 nq vdd sg13_lv_pmos l=1.3e-07 w=1.2e-06
Xi2_nmos _net1 i2 vss vss sg13_lv_nmos l=1.3e-07 w=7.8e-07
Xi2_pmos nq i2 vdd vdd sg13_lv_pmos l=1.3e-07 w=1.2e-06
Xn_pd vss nq q vss sg13_lv_nmos l=1.3e-07 w=2.8e-06
Xq_pu vdd nq q vdd sg13_lv_pmos l=1.3e-07 w=4.4e-06
.ends SP6TDec_and3_x1

.subckt SP6TDec_and2_x1 vdd vss q i0 i1
Xi0_nmos nq i0 _net0 vss sg13_lv_nmos l=1.3e-07 w=7.8e-07
Xi0_pmos vdd i0 nq vdd sg13_lv_pmos l=1.3e-07 w=1.2e-06
Xi1_nmos _net0 i1 vss vss sg13_lv_nmos l=1.3e-07 w=7.8e-07
Xi1_pmos nq i1 vdd vdd sg13_lv_pmos l=1.3e-07 w=1.2e-06
Xn_pd vss nq q vss sg13_lv_nmos l=1.3e-07 w=2.8e-06
Xq_pu vdd nq q vdd sg13_lv_pmos l=1.3e-07 w=4.4e-06
.ends SP6TDec_and2_x1

.subckt SP6TRowPredecoders_3_2B vss vdd clk a[0] a[1] a[2] a[3] a[4] pd[0][0] pd[0][1] pd[0][2] pd[0][3] pd[0][4] pd[0][5] pd[0][6] pd[0][7] page[0] page[1] page[2] page[3]
Xaff[0] vdd vss a[0] clk aint[0] SP6TDec_dff_x1
Xaff[1] vdd vss a[1] clk aint[1] SP6TDec_dff_x1
Xaff[2] vdd vss a[2] clk aint[2] SP6TDec_dff_x1
Xaff[3] vdd vss a[3] clk aint[3] SP6TDec_dff_x1
Xaff[4] vdd vss a[4] clk aint[4] SP6TDec_dff_x1
Xainv[0] vdd vss aint[0] aint_n[0] SP6TDec_inv_x1
Xainv[1] vdd vss aint[1] aint_n[1] SP6TDec_inv_x1
Xainv[2] vdd vss aint[2] aint_n[2] SP6TDec_inv_x1
Xainv[3] vdd vss aint[3] aint_n[3] SP6TDec_inv_x1
Xainv[4] vdd vss aint[4] aint_n[4] SP6TDec_inv_x1
Xpd[0]and[0] vdd vss pd[0][0] aint_n[0] aint_n[1] aint_n[2] SP6TDec_and3_x1
Xpd[0]and[1] vdd vss pd[0][1] aint[0] aint_n[1] aint_n[2] SP6TDec_and3_x1
Xpd[0]and[2] vdd vss pd[0][2] aint_n[0] aint[1] aint_n[2] SP6TDec_and3_x1
Xpd[0]and[3] vdd vss pd[0][3] aint[0] aint[1] aint_n[2] SP6TDec_and3_x1
Xpd[0]and[4] vdd vss pd[0][4] aint_n[0] aint_n[1] aint[2] SP6TDec_and3_x1
Xpd[0]and[5] vdd vss pd[0][5] aint[0] aint_n[1] aint[2] SP6TDec_and3_x1
Xpd[0]and[6] vdd vss pd[0][6] aint_n[0] aint[1] aint[2] SP6TDec_and3_x1
Xpd[0]and[7] vdd vss pd[0][7] aint[0] aint[1] aint[2] SP6TDec_and3_x1
Xpage_and[0] vdd vss page[0] aint_n[3] aint_n[4] SP6TDec_and2_x1
Xpage_and[1] vdd vss page[1] aint[3] aint_n[4] SP6TDec_and2_x1
Xpage_and[2] vdd vss page[2] aint_n[3] aint[4] SP6TDec_and2_x1
Xpage_and[3] vdd vss page[3] aint[3] aint[4] SP6TDec_and2_x1
.ends SP6TRowPredecoders_3_2B

.subckt SP6TRowDecoderNand3X2 vss vdd pd[0][0] pd[0][1] page wl_en wl_n[0] wl_n[1]
Xnmos[0] wl_n[0] wl_en int[0] vss sg13_lv_nmos l=1.3e-07 w=4.9e-07
Xnmos[1] int[0] pd[0][0] int[1] vss sg13_lv_nmos l=1.3e-07 w=4.9e-07
Xnmos[2] int[1] page vss vss sg13_lv_nmos l=1.3e-07 w=4.9e-07
Xnmos[3] vss page int[2] vss sg13_lv_nmos l=1.3e-07 w=4.9e-07
Xnmos[4] int[2] pd[0][1] int[3] vss sg13_lv_nmos l=1.3e-07 w=4.9e-07
Xnmos[5] int[3] wl_en wl_n[1] vss sg13_lv_nmos l=1.3e-07 w=4.9e-07
Xpmos[0] wl_n[0] wl_en vdd vdd sg13_lv_pmos l=1.3e-07 w=4.9e-07
Xpmos[1] vdd pd[0][0] wl_n[0] vdd sg13_lv_pmos l=1.3e-07 w=4.9e-07
Xpmos[2] wl_n[0] page vdd vdd sg13_lv_pmos l=1.3e-07 w=4.9e-07
Xpmos[3] vdd page wl_n[1] vdd sg13_lv_pmos l=1.3e-07 w=4.9e-07
Xpmos[4] wl_n[1] pd[0][1] vdd vdd sg13_lv_pmos l=1.3e-07 w=4.9e-07
Xpmos[5] vdd wl_en wl_n[1] vdd sg13_lv_pmos l=1.3e-07 w=4.9e-07
.ends SP6TRowDecoderNand3X2

.subckt SP6TWLDrive_26LN100WN26LP200WP vss vdd wl_n wl_drive
Xnmos1 vss wl_n wl_drive vss sg13_lv_nmos l=1.3e-07 w=5e-07
Xnmos2 wl_drive wl_n vss vss sg13_lv_nmos l=1.3e-07 w=5e-07
Xpmos1 vdd wl_n wl_drive vdd sg13_lv_pmos l=1.3e-07 w=1e-06
Xpmos2 wl_drive wl_n vdd vdd sg13_lv_pmos l=1.3e-07 w=1e-06
.ends SP6TWLDrive_26LN100WN26LP200WP

.subckt SP6TRowDecoderDriverPage_2PD8R vss vdd wl[0] wl[1] wl[2] wl[3] wl[4] wl[5] wl[6] wl[7] pd[0][0] pd[0][1] pd[0][2] pd[0][3] pd[0][4] pd[0][5] pd[0][6] pd[0][7] page wl_en
Xnand3[0] vss vdd pd[0][0] pd[0][1] page wl_en wl_n[0] wl_n[1] SP6TRowDecoderNand3X2
Xnand3[1] vss vdd pd[0][2] pd[0][3] page wl_en wl_n[2] wl_n[3] SP6TRowDecoderNand3X2
Xnand3[2] vss vdd pd[0][4] pd[0][5] page wl_en wl_n[4] wl_n[5] SP6TRowDecoderNand3X2
Xnand3[3] vss vdd pd[0][6] pd[0][7] page wl_en wl_n[6] wl_n[7] SP6TRowDecoderNand3X2
Xdrive[0] vss vdd wl_n[0] wl[0] SP6TWLDrive_26LN100WN26LP200WP
Xdrive[1] vss vdd wl_n[1] wl[1] SP6TWLDrive_26LN100WN26LP200WP
Xdrive[2] vss vdd wl_n[2] wl[2] SP6TWLDrive_26LN100WN26LP200WP
Xdrive[3] vss vdd wl_n[3] wl[3] SP6TWLDrive_26LN100WN26LP200WP
Xdrive[4] vss vdd wl_n[4] wl[4] SP6TWLDrive_26LN100WN26LP200WP
Xdrive[5] vss vdd wl_n[5] wl[5] SP6TWLDrive_26LN100WN26LP200WP
Xdrive[6] vss vdd wl_n[6] wl[6] SP6TWLDrive_26LN100WN26LP200WP
Xdrive[7] vss vdd wl_n[7] wl[7] SP6TWLDrive_26LN100WN26LP200WP
.ends SP6TRowDecoderDriverPage_2PD8R

.subckt SP6TRowDecoderBulkConn vdd vss
.ends SP6TRowDecoderBulkConn

.subckt SP6TRowDecoder_3_2B vss vdd a[0] a[1] a[2] a[3] a[4] clk wl_en wl[0] wl[1] wl[2] wl[3] wl[4] wl[5] wl[6] wl[7] wl[8] wl[9] wl[10] wl[11] wl[12] wl[13] wl[14] wl[15] wl[16] wl[17] wl[18] wl[19] wl[20] wl[21] wl[22] wl[23] wl[24] wl[25] wl[26] wl[27] wl[28] wl[29] wl[30] wl[31]
Xpredec vss vdd clk a[0] a[1] a[2] a[3] a[4] pd[0][0] pd[0][1] pd[0][2] pd[0][3] pd[0][4] pd[0][5] pd[0][6] pd[0][7] page[0] page[1] page[2] page[3] SP6TRowPredecoders_3_2B
Xpage[0] vss vdd wl[0] wl[1] wl[2] wl[3] wl[4] wl[5] wl[6] wl[7] pd[0][0] pd[0][1] pd[0][2] pd[0][3] pd[0][4] pd[0][5] pd[0][6] pd[0][7] page[0] wl_en SP6TRowDecoderDriverPage_2PD8R
Xpage[1] vss vdd wl[8] wl[9] wl[10] wl[11] wl[12] wl[13] wl[14] wl[15] pd[0][0] pd[0][1] pd[0][2] pd[0][3] pd[0][4] pd[0][5] pd[0][6] pd[0][7] page[1] wl_en SP6TRowDecoderDriverPage_2PD8R
Xpage[2] vss vdd wl[16] wl[17] wl[18] wl[19] wl[20] wl[21] wl[22] wl[23] pd[0][0] pd[0][1] pd[0][2] pd[0][3] pd[0][4] pd[0][5] pd[0][6] pd[0][7] page[2] wl_en SP6TRowDecoderDriverPage_2PD8R
Xpage[3] vss vdd wl[24] wl[25] wl[26] wl[27] wl[28] wl[29] wl[30] wl[31] pd[0][0] pd[0][1] pd[0][2] pd[0][3] pd[0][4] pd[0][5] pd[0][6] pd[0][7] page[3] wl_en SP6TRowDecoderDriverPage_2PD8R
Xbulkcon[0] vdd vss SP6TRowDecoderBulkConn
Xbulkcon[1] vdd vss SP6TRowDecoderBulkConn
Xbulkcon[2] vdd vss SP6TRowDecoderBulkConn
.ends SP6TRowDecoder_3_2B

.subckt SP6TRowPeriphery_3_2_2 vss vdd clk a[0] a[1] a[2] a[3] a[4] a[5] a[6] wl[0] wl[1] wl[2] wl[3] wl[4] wl[5] wl[6] wl[7] wl[8] wl[9] wl[10] wl[11] wl[12] wl[13] wl[14] wl[15] wl[16] wl[17] wl[18] wl[19] wl[20] wl[21] wl[22] wl[23] wl[24] wl[25] wl[26] wl[27] wl[28] wl[29] wl[30] wl[31] mux[0] mux[1] mux[2] mux[3] columnclk precharge_n we_en
Xclkgen vss vdd clk decodeclk columnclk precharge_n wl_en we_en SP6TClockGenerator_8S1R
Xcoldec vss vdd decodeclk a[0] a[1] mux[0] mux[1] mux[2] mux[3] SP6TLatchedDecoder_2A2R
Xrowdec vss vdd a[2] a[3] a[4] a[5] a[6] decodeclk wl_en wl[0] wl[1] wl[2] wl[3] wl[4] wl[5] wl[6] wl[7] wl[8] wl[9] wl[10] wl[11] wl[12] wl[13] wl[14] wl[15] wl[16] wl[17] wl[18] wl[19] wl[20] wl[21] wl[22] wl[23] wl[24] wl[25] wl[26] wl[27] wl[28] wl[29] wl[30] wl[31] SP6TRowDecoder_3_2B
.ends SP6TRowPeriphery_3_2_2

.subckt SP6TCell wl bl bl_n vdd vss
Xpu1 vdd bit_n bit vdd sg13_lv_pmos l=1.3e-07 w=1.5e-07
Xpd1 bit bit_n vss vss sg13_lv_nmos l=1.3e-07 w=2e-07
Xpu2 vdd bit bit_n vdd sg13_lv_pmos l=1.3e-07 w=1.5e-07
Xpd2 bit_n bit vss vss sg13_lv_nmos l=1.3e-07 w=2e-07
Xpg1 bit wl bl vss sg13_lv_nmos l=1.3e-07 w=2e-07
Xpg2 bit_n wl bl_n vss sg13_lv_nmos l=1.3e-07 w=2e-07
.ends SP6TCell

.subckt SP6TArray_2X1 vss vdd wl[0] wl[1] bl[0] bl_n[0]
Xinst0x0 wl[0] bl[0] bl_n[0] vdd vss SP6TCell
Xinst1x0 wl[1] bl[0] bl_n[0] vdd vss SP6TCell
.ends SP6TArray_2X1

.subckt SP6TArray_2X2 vss vdd wl[0] wl[1] bl[0] bl_n[0] bl[1] bl_n[1]
Xinst0x0 vss vdd wl[0] wl[1] bl[0] bl_n[0] SP6TArray_2X1
Xinst0x1 vss vdd wl[0] wl[1] bl[1] bl_n[1] SP6TArray_2X1
.ends SP6TArray_2X2

.subckt SP6TArray_4X2 vss vdd wl[0] wl[1] wl[2] wl[3] bl[0] bl_n[0] bl[1] bl_n[1]
Xinst0x0 vss vdd wl[0] wl[1] bl[0] bl_n[0] bl[1] bl_n[1] SP6TArray_2X2
Xinst1x0 vss vdd wl[2] wl[3] bl[0] bl_n[0] bl[1] bl_n[1] SP6TArray_2X2
.ends SP6TArray_4X2

.subckt SP6TArray_4X4 vss vdd wl[0] wl[1] wl[2] wl[3] bl[0] bl_n[0] bl[1] bl_n[1] bl[2] bl_n[2] bl[3] bl_n[3]
Xinst0x0 vss vdd wl[0] wl[1] wl[2] wl[3] bl[0] bl_n[0] bl[1] bl_n[1] SP6TArray_4X2
Xinst0x1 vss vdd wl[0] wl[1] wl[2] wl[3] bl[2] bl_n[2] bl[3] bl_n[3] SP6TArray_4X2
.ends SP6TArray_4X4

.subckt SP6TArray_8X4 vss vdd wl[0] wl[1] wl[2] wl[3] wl[4] wl[5] wl[6] wl[7] bl[0] bl_n[0] bl[1] bl_n[1] bl[2] bl_n[2] bl[3] bl_n[3]
Xinst0x0 vss vdd wl[0] wl[1] wl[2] wl[3] bl[0] bl_n[0] bl[1] bl_n[1] bl[2] bl_n[2] bl[3] bl_n[3] SP6TArray_4X4
Xinst1x0 vss vdd wl[4] wl[5] wl[6] wl[7] bl[0] bl_n[0] bl[1] bl_n[1] bl[2] bl_n[2] bl[3] bl_n[3] SP6TArray_4X4
.ends SP6TArray_8X4

.subckt SP6TArray_8X8 vss vdd wl[0] wl[1] wl[2] wl[3] wl[4] wl[5] wl[6] wl[7] bl[0] bl_n[0] bl[1] bl_n[1] bl[2] bl_n[2] bl[3] bl_n[3] bl[4] bl_n[4] bl[5] bl_n[5] bl[6] bl_n[6] bl[7] bl_n[7]
Xinst0x0 vss vdd wl[0] wl[1] wl[2] wl[3] wl[4] wl[5] wl[6] wl[7] bl[0] bl_n[0] bl[1] bl_n[1] bl[2] bl_n[2] bl[3] bl_n[3] SP6TArray_8X4
Xinst0x1 vss vdd wl[0] wl[1] wl[2] wl[3] wl[4] wl[5] wl[6] wl[7] bl[4] bl_n[4] bl[5] bl_n[5] bl[6] bl_n[6] bl[7] bl_n[7] SP6TArray_8X4
.ends SP6TArray_8X8

.subckt SP6TArray_16X8 vss vdd wl[0] wl[1] wl[2] wl[3] wl[4] wl[5] wl[6] wl[7] wl[8] wl[9] wl[10] wl[11] wl[12] wl[13] wl[14] wl[15] bl[0] bl_n[0] bl[1] bl_n[1] bl[2] bl_n[2] bl[3] bl_n[3] bl[4] bl_n[4] bl[5] bl_n[5] bl[6] bl_n[6] bl[7] bl_n[7]
Xinst0x0 vss vdd wl[0] wl[1] wl[2] wl[3] wl[4] wl[5] wl[6] wl[7] bl[0] bl_n[0] bl[1] bl_n[1] bl[2] bl_n[2] bl[3] bl_n[3] bl[4] bl_n[4] bl[5] bl_n[5] bl[6] bl_n[6] bl[7] bl_n[7] SP6TArray_8X8
Xinst1x0 vss vdd wl[8] wl[9] wl[10] wl[11] wl[12] wl[13] wl[14] wl[15] bl[0] bl_n[0] bl[1] bl_n[1] bl[2] bl_n[2] bl[3] bl_n[3] bl[4] bl_n[4] bl[5] bl_n[5] bl[6] bl_n[6] bl[7] bl_n[7] SP6TArray_8X8
.ends SP6TArray_16X8

.subckt SP6TArray_16X16 vss vdd wl[0] wl[1] wl[2] wl[3] wl[4] wl[5] wl[6] wl[7] wl[8] wl[9] wl[10] wl[11] wl[12] wl[13] wl[14] wl[15] bl[0] bl_n[0] bl[1] bl_n[1] bl[2] bl_n[2] bl[3] bl_n[3] bl[4] bl_n[4] bl[5] bl_n[5] bl[6] bl_n[6] bl[7] bl_n[7] bl[8] bl_n[8] bl[9] bl_n[9] bl[10] bl_n[10] bl[11] bl_n[11] bl[12] bl_n[12] bl[13] bl_n[13] bl[14] bl_n[14] bl[15] bl_n[15]
Xinst0x0 vss vdd wl[0] wl[1] wl[2] wl[3] wl[4] wl[5] wl[6] wl[7] wl[8] wl[9] wl[10] wl[11] wl[12] wl[13] wl[14] wl[15] bl[0] bl_n[0] bl[1] bl_n[1] bl[2] bl_n[2] bl[3] bl_n[3] bl[4] bl_n[4] bl[5] bl_n[5] bl[6] bl_n[6] bl[7] bl_n[7] SP6TArray_16X8
Xinst0x1 vss vdd wl[0] wl[1] wl[2] wl[3] wl[4] wl[5] wl[6] wl[7] wl[8] wl[9] wl[10] wl[11] wl[12] wl[13] wl[14] wl[15] bl[8] bl_n[8] bl[9] bl_n[9] bl[10] bl_n[10] bl[11] bl_n[11] bl[12] bl_n[12] bl[13] bl_n[13] bl[14] bl_n[14] bl[15] bl_n[15] SP6TArray_16X8
.ends SP6TArray_16X16

.subckt SP6TArray_16X32 vss vdd wl[0] wl[1] wl[2] wl[3] wl[4] wl[5] wl[6] wl[7] wl[8] wl[9] wl[10] wl[11] wl[12] wl[13] wl[14] wl[15] bl[0] bl_n[0] bl[1] bl_n[1] bl[2] bl_n[2] bl[3] bl_n[3] bl[4] bl_n[4] bl[5] bl_n[5] bl[6] bl_n[6] bl[7] bl_n[7] bl[8] bl_n[8] bl[9] bl_n[9] bl[10] bl_n[10] bl[11] bl_n[11] bl[12] bl_n[12] bl[13] bl_n[13] bl[14] bl_n[14] bl[15] bl_n[15] bl[16] bl_n[16] bl[17] bl_n[17] bl[18] bl_n[18] bl[19] bl_n[19] bl[20] bl_n[20] bl[21] bl_n[21] bl[22] bl_n[22] bl[23] bl_n[23] bl[24] bl_n[24] bl[25] bl_n[25] bl[26] bl_n[26] bl[27] bl_n[27] bl[28] bl_n[28] bl[29] bl_n[29] bl[30] bl_n[30] bl[31] bl_n[31]
Xinst0x0 vss vdd wl[0] wl[1] wl[2] wl[3] wl[4] wl[5] wl[6] wl[7] wl[8] wl[9] wl[10] wl[11] wl[12] wl[13] wl[14] wl[15] bl[0] bl_n[0] bl[1] bl_n[1] bl[2] bl_n[2] bl[3] bl_n[3] bl[4] bl_n[4] bl[5] bl_n[5] bl[6] bl_n[6] bl[7] bl_n[7] bl[8] bl_n[8] bl[9] bl_n[9] bl[10] bl_n[10] bl[11] bl_n[11] bl[12] bl_n[12] bl[13] bl_n[13] bl[14] bl_n[14] bl[15] bl_n[15] SP6TArray_16X16
Xinst0x1 vss vdd wl[0] wl[1] wl[2] wl[3] wl[4] wl[5] wl[6] wl[7] wl[8] wl[9] wl[10] wl[11] wl[12] wl[13] wl[14] wl[15] bl[16] bl_n[16] bl[17] bl_n[17] bl[18] bl_n[18] bl[19] bl_n[19] bl[20] bl_n[20] bl[21] bl_n[21] bl[22] bl_n[22] bl[23] bl_n[23] bl[24] bl_n[24] bl[25] bl_n[25] bl[26] bl_n[26] bl[27] bl_n[27] bl[28] bl_n[28] bl[29] bl_n[29] bl[30] bl_n[30] bl[31] bl_n[31] SP6TArray_16X16
.ends SP6TArray_16X32

.subckt SP6TBulkConn vdd vss bl bl_n
.ends SP6TBulkConn

.subckt SP6TBulkConnRow_2 vss vdd bl[0] bl_n[0] bl[1] bl_n[1]
Xinst0 vdd vss bl[0] bl_n[0] SP6TBulkConn
Xinst1 vdd vss bl[1] bl_n[1] SP6TBulkConn
.ends SP6TBulkConnRow_2

.subckt SP6TBulkConnRow_4 vss vdd bl[0] bl_n[0] bl[1] bl_n[1] bl[2] bl_n[2] bl[3] bl_n[3]
Xinst0 vss vdd bl[0] bl_n[0] bl[1] bl_n[1] SP6TBulkConnRow_2
Xinst1 vss vdd bl[2] bl_n[2] bl[3] bl_n[3] SP6TBulkConnRow_2
.ends SP6TBulkConnRow_4

.subckt SP6TBulkConnRow_8 vss vdd bl[0] bl_n[0] bl[1] bl_n[1] bl[2] bl_n[2] bl[3] bl_n[3] bl[4] bl_n[4] bl[5] bl_n[5] bl[6] bl_n[6] bl[7] bl_n[7]
Xinst0 vss vdd bl[0] bl_n[0] bl[1] bl_n[1] bl[2] bl_n[2] bl[3] bl_n[3] SP6TBulkConnRow_4
Xinst1 vss vdd bl[4] bl_n[4] bl[5] bl_n[5] bl[6] bl_n[6] bl[7] bl_n[7] SP6TBulkConnRow_4
.ends SP6TBulkConnRow_8

.subckt SP6TBulkConnRow_16 vss vdd bl[0] bl_n[0] bl[1] bl_n[1] bl[2] bl_n[2] bl[3] bl_n[3] bl[4] bl_n[4] bl[5] bl_n[5] bl[6] bl_n[6] bl[7] bl_n[7] bl[8] bl_n[8] bl[9] bl_n[9] bl[10] bl_n[10] bl[11] bl_n[11] bl[12] bl_n[12] bl[13] bl_n[13] bl[14] bl_n[14] bl[15] bl_n[15]
Xinst0 vss vdd bl[0] bl_n[0] bl[1] bl_n[1] bl[2] bl_n[2] bl[3] bl_n[3] bl[4] bl_n[4] bl[5] bl_n[5] bl[6] bl_n[6] bl[7] bl_n[7] SP6TBulkConnRow_8
Xinst1 vss vdd bl[8] bl_n[8] bl[9] bl_n[9] bl[10] bl_n[10] bl[11] bl_n[11] bl[12] bl_n[12] bl[13] bl_n[13] bl[14] bl_n[14] bl[15] bl_n[15] SP6TBulkConnRow_8
.ends SP6TBulkConnRow_16

.subckt SP6TBulkConnRow_32 vss vdd bl[0] bl_n[0] bl[1] bl_n[1] bl[2] bl_n[2] bl[3] bl_n[3] bl[4] bl_n[4] bl[5] bl_n[5] bl[6] bl_n[6] bl[7] bl_n[7] bl[8] bl_n[8] bl[9] bl_n[9] bl[10] bl_n[10] bl[11] bl_n[11] bl[12] bl_n[12] bl[13] bl_n[13] bl[14] bl_n[14] bl[15] bl_n[15] bl[16] bl_n[16] bl[17] bl_n[17] bl[18] bl_n[18] bl[19] bl_n[19] bl[20] bl_n[20] bl[21] bl_n[21] bl[22] bl_n[22] bl[23] bl_n[23] bl[24] bl_n[24] bl[25] bl_n[25] bl[26] bl_n[26] bl[27] bl_n[27] bl[28] bl_n[28] bl[29] bl_n[29] bl[30] bl_n[30] bl[31] bl_n[31]
Xinst0 vss vdd bl[0] bl_n[0] bl[1] bl_n[1] bl[2] bl_n[2] bl[3] bl_n[3] bl[4] bl_n[4] bl[5] bl_n[5] bl[6] bl_n[6] bl[7] bl_n[7] bl[8] bl_n[8] bl[9] bl_n[9] bl[10] bl_n[10] bl[11] bl_n[11] bl[12] bl_n[12] bl[13] bl_n[13] bl[14] bl_n[14] bl[15] bl_n[15] SP6TBulkConnRow_16
Xinst1 vss vdd bl[16] bl_n[16] bl[17] bl_n[17] bl[18] bl_n[18] bl[19] bl_n[19] bl[20] bl_n[20] bl[21] bl_n[21] bl[22] bl_n[22] bl[23] bl_n[23] bl[24] bl_n[24] bl[25] bl_n[25] bl[26] bl_n[26] bl[27] bl_n[27] bl[28] bl_n[28] bl[29] bl_n[29] bl[30] bl_n[30] bl[31] bl_n[31] SP6TBulkConnRow_16
.ends SP6TBulkConnRow_32

.subckt SP6TArray_32X32BC vss vdd wl[0] wl[1] wl[2] wl[3] wl[4] wl[5] wl[6] wl[7] wl[8] wl[9] wl[10] wl[11] wl[12] wl[13] wl[14] wl[15] wl[16] wl[17] wl[18] wl[19] wl[20] wl[21] wl[22] wl[23] wl[24] wl[25] wl[26] wl[27] wl[28] wl[29] wl[30] wl[31] bl[0] bl_n[0] bl[1] bl_n[1] bl[2] bl_n[2] bl[3] bl_n[3] bl[4] bl_n[4] bl[5] bl_n[5] bl[6] bl_n[6] bl[7] bl_n[7] bl[8] bl_n[8] bl[9] bl_n[9] bl[10] bl_n[10] bl[11] bl_n[11] bl[12] bl_n[12] bl[13] bl_n[13] bl[14] bl_n[14] bl[15] bl_n[15] bl[16] bl_n[16] bl[17] bl_n[17] bl[18] bl_n[18] bl[19] bl_n[19] bl[20] bl_n[20] bl[21] bl_n[21] bl[22] bl_n[22] bl[23] bl_n[23] bl[24] bl_n[24] bl[25] bl_n[25] bl[26] bl_n[26] bl[27] bl_n[27] bl[28] bl_n[28] bl[29] bl_n[29] bl[30] bl_n[30] bl[31] bl_n[31]
Xinst0x0 vss vdd wl[0] wl[1] wl[2] wl[3] wl[4] wl[5] wl[6] wl[7] wl[8] wl[9] wl[10] wl[11] wl[12] wl[13] wl[14] wl[15] bl[0] bl_n[0] bl[1] bl_n[1] bl[2] bl_n[2] bl[3] bl_n[3] bl[4] bl_n[4] bl[5] bl_n[5] bl[6] bl_n[6] bl[7] bl_n[7] bl[8] bl_n[8] bl[9] bl_n[9] bl[10] bl_n[10] bl[11] bl_n[11] bl[12] bl_n[12] bl[13] bl_n[13] bl[14] bl_n[14] bl[15] bl_n[15] bl[16] bl_n[16] bl[17] bl_n[17] bl[18] bl_n[18] bl[19] bl_n[19] bl[20] bl_n[20] bl[21] bl_n[21] bl[22] bl_n[22] bl[23] bl_n[23] bl[24] bl_n[24] bl[25] bl_n[25] bl[26] bl_n[26] bl[27] bl_n[27] bl[28] bl_n[28] bl[29] bl_n[29] bl[30] bl_n[30] bl[31] bl_n[31] SP6TArray_16X32
Xinst1x0 vss vdd wl[16] wl[17] wl[18] wl[19] wl[20] wl[21] wl[22] wl[23] wl[24] wl[25] wl[26] wl[27] wl[28] wl[29] wl[30] wl[31] bl[0] bl_n[0] bl[1] bl_n[1] bl[2] bl_n[2] bl[3] bl_n[3] bl[4] bl_n[4] bl[5] bl_n[5] bl[6] bl_n[6] bl[7] bl_n[7] bl[8] bl_n[8] bl[9] bl_n[9] bl[10] bl_n[10] bl[11] bl_n[11] bl[12] bl_n[12] bl[13] bl_n[13] bl[14] bl_n[14] bl[15] bl_n[15] bl[16] bl_n[16] bl[17] bl_n[17] bl[18] bl_n[18] bl[19] bl_n[19] bl[20] bl_n[20] bl[21] bl_n[21] bl[22] bl_n[22] bl[23] bl_n[23] bl[24] bl_n[24] bl[25] bl_n[25] bl[26] bl_n[26] bl[27] bl_n[27] bl[28] bl_n[28] bl[29] bl_n[29] bl[30] bl_n[30] bl[31] bl_n[31] SP6TArray_16X32
Xbcrow vss vdd bl[0] bl_n[0] bl[1] bl_n[1] bl[2] bl_n[2] bl[3] bl_n[3] bl[4] bl_n[4] bl[5] bl_n[5] bl[6] bl_n[6] bl[7] bl_n[7] bl[8] bl_n[8] bl[9] bl_n[9] bl[10] bl_n[10] bl[11] bl_n[11] bl[12] bl_n[12] bl[13] bl_n[13] bl[14] bl_n[14] bl[15] bl_n[15] bl[16] bl_n[16] bl[17] bl_n[17] bl[18] bl_n[18] bl[19] bl_n[19] bl[20] bl_n[20] bl[21] bl_n[21] bl[22] bl_n[22] bl[23] bl_n[23] bl[24] bl_n[24] bl[25] bl_n[25] bl[26] bl_n[26] bl[27] bl_n[27] bl[28] bl_n[28] bl[29] bl_n[29] bl[30] bl_n[30] bl[31] bl_n[31] SP6TBulkConnRow_32
Xbottombcrow vss vdd bl[0] bl_n[0] bl[1] bl_n[1] bl[2] bl_n[2] bl[3] bl_n[3] bl[4] bl_n[4] bl[5] bl_n[5] bl[6] bl_n[6] bl[7] bl_n[7] bl[8] bl_n[8] bl[9] bl_n[9] bl[10] bl_n[10] bl[11] bl_n[11] bl[12] bl_n[12] bl[13] bl_n[13] bl[14] bl_n[14] bl[15] bl_n[15] bl[16] bl_n[16] bl[17] bl_n[17] bl[18] bl_n[18] bl[19] bl_n[19] bl[20] bl_n[20] bl[21] bl_n[21] bl[22] bl_n[22] bl[23] bl_n[23] bl[24] bl_n[24] bl[25] bl_n[25] bl[26] bl_n[26] bl[27] bl_n[27] bl[28] bl_n[28] bl[29] bl_n[29] bl[30] bl_n[30] bl[31] bl_n[31] SP6TBulkConnRow_32
Xtopbcrow vss vdd bl[0] bl_n[0] bl[1] bl_n[1] bl[2] bl_n[2] bl[3] bl_n[3] bl[4] bl_n[4] bl[5] bl_n[5] bl[6] bl_n[6] bl[7] bl_n[7] bl[8] bl_n[8] bl[9] bl_n[9] bl[10] bl_n[10] bl[11] bl_n[11] bl[12] bl_n[12] bl[13] bl_n[13] bl[14] bl_n[14] bl[15] bl_n[15] bl[16] bl_n[16] bl[17] bl_n[17] bl[18] bl_n[18] bl[19] bl_n[19] bl[20] bl_n[20] bl[21] bl_n[21] bl[22] bl_n[22] bl[23] bl_n[23] bl[24] bl_n[24] bl[25] bl_n[25] bl[26] bl_n[26] bl[27] bl_n[27] bl[28] bl_n[28] bl[29] bl_n[29] bl[30] bl_n[30] bl[31] bl_n[31] SP6TBulkConnRow_32
.ends SP6TArray_32X32BC

.subckt SP6TPrecharge vdd bl bl_n precharge_n
Xpc1 vdd precharge_n bl vdd sg13_lv_pmos l=1.3e-07 w=5e-07
Xpc2 bl precharge_n bl_n vdd sg13_lv_pmos l=1.3e-07 w=5e-07
Xpc3 bl_n precharge_n vdd vdd sg13_lv_pmos l=1.3e-07 w=5e-07
.ends SP6TPrecharge

.subckt SP6TColMux_4C bl[0] bl_n[0] mux[0] bl[1] bl_n[1] mux[1] bl[2] bl_n[2] mux[2] bl[3] bl_n[3] mux[3] vss muxbl muxbl_n
Xpgbl0 muxbl mux[0] bl[0] vss sg13_lv_nmos l=1.3e-07 w=3.5e-06
Xpgbln0 bl_n[0] mux[0] muxbl_n vss sg13_lv_nmos l=1.3e-07 w=3.5e-06
Xpgbl1 bl[1] mux[1] muxbl vss sg13_lv_nmos l=1.3e-07 w=3.5e-06
Xpgbln1 muxbl_n mux[1] bl_n[1] vss sg13_lv_nmos l=1.3e-07 w=3.5e-06
Xpgbl2 muxbl mux[2] bl[2] vss sg13_lv_nmos l=1.3e-07 w=3.5e-06
Xpgbln2 bl_n[2] mux[2] muxbl_n vss sg13_lv_nmos l=1.3e-07 w=3.5e-06
Xpgbl3 bl[3] mux[3] muxbl vss sg13_lv_nmos l=1.3e-07 w=3.5e-06
Xpgbln3 muxbl_n mux[3] bl_n[3] vss sg13_lv_nmos l=1.3e-07 w=3.5e-06
.ends SP6TColMux_4C

.subckt nsnrlatch_x1 vdd vss nset nrst q nq
Xnset_nmos q nset _net0 vss sg13_lv_nmos l=1.3e-07 w=1.31e-06
Xnset_pmos vdd nset q vdd sg13_lv_pmos l=1.3e-07 w=1.3e-06
Xnq_nmos _net0 nq vss vss sg13_lv_nmos l=1.3e-07 w=1.31e-06
Xnq_pmos q nq vdd vdd sg13_lv_pmos l=1.3e-07 w=1.3e-06
Xq_nmos vss q _net1 vss sg13_lv_nmos l=1.3e-07 w=1.31e-06
Xq_pmos vdd q nq vdd sg13_lv_pmos l=1.3e-07 w=1.3e-06
Xnrst_nmos _net1 nrst nq vss sg13_lv_nmos l=1.3e-07 w=1.31e-06
Xnrst_pmos nq nrst vdd vdd sg13_lv_pmos l=1.3e-07 w=1.3e-06
.ends nsnrlatch_x1

.subckt dff_x1 vdd vss i clk q
Xclk_nmos _clk_n clk vss vss sg13_lv_nmos l=1.3e-07 w=7.8e-07
Xclk_pmos _clk_n clk vdd vdd sg13_lv_pmos l=1.3e-07 w=7.8e-07
Xclk_n_nmos0 vss _clk_n _clk_buf vss sg13_lv_nmos l=1.3e-07 w=7.8e-07
Xclk_n_pmos0 vdd _clk_n _clk_buf vdd sg13_lv_pmos l=1.3e-07 w=7.8e-07
Xi_nmos _u i vss vss sg13_lv_nmos l=1.3e-07 w=7.8e-07
Xi_pmos _u i vdd vdd sg13_lv_pmos l=1.3e-07 w=7.8e-07
Xu_nmos vss _u _net0 vss sg13_lv_nmos l=1.3e-07 w=7.8e-07
Xu_pmos vdd _u _net1 vdd sg13_lv_pmos l=1.3e-07 w=7.8e-07
Xclk_n_nmos1 _net0 _clk_n _dff_m vss sg13_lv_nmos l=1.3e-07 w=7.8e-07
Xclk_buf_pmos0 _net1 _clk_buf _dff_m vdd sg13_lv_pmos l=1.3e-07 w=7.8e-07
Xclk_buf_nmos0 _dff_m _clk_buf _net2 vss sg13_lv_nmos l=1.3e-07 w=7.8e-07
Xclk_n_pmos1 _dff_m _clk_n _net3 vdd sg13_lv_pmos l=1.3e-07 w=7.8e-07
Xy_nmos _net2 _y vss vss sg13_lv_nmos l=1.3e-07 w=7.8e-07
Xy_pmos _net3 _y vdd vdd sg13_lv_pmos l=1.3e-07 w=7.8e-07
Xdff_m_nmos vss _dff_m _y vss sg13_lv_nmos l=1.3e-07 w=7.8e-07
Xdff_m_pmos vdd _dff_m _y vdd sg13_lv_pmos l=1.3e-07 w=7.8e-07
Xclk_buf_nmos1 _y _clk_buf _dff_s vss sg13_lv_nmos l=1.3e-07 w=7.8e-07
Xclk_n_pmos2 _y _clk_n _dff_s vdd sg13_lv_pmos l=1.3e-07 w=7.8e-07
Xclk_n_nmos2 _dff_s _clk_n _net4 vss sg13_lv_nmos l=1.3e-07 w=7.8e-07
Xclk_buf_pmos1 _dff_s _clk_buf _net5 vdd sg13_lv_pmos l=1.3e-07 w=7.8e-07
Xq_nmos _net4 q vss vss sg13_lv_nmos l=1.3e-07 w=7.8e-07
Xq_pmos _net5 q vdd vdd sg13_lv_pmos l=1.3e-07 w=7.8e-07
Xdff_s_nmos vss _dff_s q vss sg13_lv_nmos l=1.3e-07 w=8.3e-07
Xdff_s_pmos vdd _dff_s q vdd sg13_lv_pmos l=1.3e-07 w=8.2e-07
.ends dff_x1

.subckt nor2_x0 vdd vss nq i0 i1
Xi0_nmos vss i0 nq vss sg13_lv_nmos l=1.3e-07 w=7.8e-07
Xi0_pmos vdd i0 _net0 vdd sg13_lv_pmos l=1.3e-07 w=7.8e-07
Xi1_nmos nq i1 vss vss sg13_lv_nmos l=1.3e-07 w=7.8e-07
Xi1_pmos _net0 i1 nq vdd sg13_lv_pmos l=1.3e-07 w=7.8e-07
.ends nor2_x0

.subckt SP6TReadWrite_4M vss vdd d q bl bl_n clk we_n
Xsenseamp vdd vss bl_n bl q noconn nsnrlatch_x1
Xd_ff vdd vss d clk d_l dff_x1
Xd_inv vdd vss d_l d_n inv_x0
Xnora vdd vss bl_pd_g d_l we_n nor2_x0
Xnorb vdd vss bln_pd_g d_n we_n nor2_x0
Xbl_pd bl bl_pd_g vss vss sg13_lv_nmos l=1.3e-07 w=1.9e-06
Xbln_pd vss bln_pd_g bl_n vss sg13_lv_nmos l=1.3e-07 w=1.9e-06
.ends SP6TReadWrite_4M

.subckt buf_x2 vdd vss i q
Xstage0_nmos _i_n i vss vss sg13_lv_nmos l=1.3e-07 w=7.8e-07
Xstage0_pmos _i_n i vdd vdd sg13_lv_pmos l=1.3e-07 w=7.8e-07
Xnmos[0] vss _i_n q vss sg13_lv_nmos l=1.3e-07 w=1.07e-06
Xpmos[0] vdd _i_n q vdd sg13_lv_pmos l=1.3e-07 w=1.06e-06
Xnmos[1] q _i_n vss vss sg13_lv_nmos l=1.3e-07 w=1.07e-06
Xpmos[1] q _i_n vdd vdd sg13_lv_pmos l=1.3e-07 w=1.06e-06
.ends buf_x2

.subckt SP6TClockWE vss vdd clkup clkdown we we_en we_n
Xclkbuf vdd vss clkup clkdown buf_x2
Xweff vdd vss we clkdown we_l dff_x1
Xwenand vdd vss we_n we_l we_en nand2_x0
.ends SP6TClockWE

.subckt SP6TColumnPeriphery_8B4M vss vdd clk precharge_n we we_en q[0] d[0] bl[0] bl_n[0] bl[1] bl_n[1] bl[2] bl_n[2] bl[3] bl_n[3] q[1] d[1] bl[4] bl_n[4] bl[5] bl_n[5] bl[6] bl_n[6] bl[7] bl_n[7] q[2] d[2] bl[8] bl_n[8] bl[9] bl_n[9] bl[10] bl_n[10] bl[11] bl_n[11] q[3] d[3] bl[12] bl_n[12] bl[13] bl_n[13] bl[14] bl_n[14] bl[15] bl_n[15] q[4] d[4] bl[16] bl_n[16] bl[17] bl_n[17] bl[18] bl_n[18] bl[19] bl_n[19] q[5] d[5] bl[20] bl_n[20] bl[21] bl_n[21] bl[22] bl_n[22] bl[23] bl_n[23] q[6] d[6] bl[24] bl_n[24] bl[25] bl_n[25] bl[26] bl_n[26] bl[27] bl_n[27] q[7] d[7] bl[28] bl_n[28] bl[29] bl_n[29] bl[30] bl_n[30] bl[31] bl_n[31] mux[0] mux[1] mux[2] mux[3]
Xprecharge[0] vdd bl[0] bl_n[0] precharge_n SP6TPrecharge
Xprecharge[1] vdd bl[1] bl_n[1] precharge_n SP6TPrecharge
Xprecharge[2] vdd bl[2] bl_n[2] precharge_n SP6TPrecharge
Xprecharge[3] vdd bl[3] bl_n[3] precharge_n SP6TPrecharge
Xprecharge[4] vdd bl[4] bl_n[4] precharge_n SP6TPrecharge
Xprecharge[5] vdd bl[5] bl_n[5] precharge_n SP6TPrecharge
Xprecharge[6] vdd bl[6] bl_n[6] precharge_n SP6TPrecharge
Xprecharge[7] vdd bl[7] bl_n[7] precharge_n SP6TPrecharge
Xprecharge[8] vdd bl[8] bl_n[8] precharge_n SP6TPrecharge
Xprecharge[9] vdd bl[9] bl_n[9] precharge_n SP6TPrecharge
Xprecharge[10] vdd bl[10] bl_n[10] precharge_n SP6TPrecharge
Xprecharge[11] vdd bl[11] bl_n[11] precharge_n SP6TPrecharge
Xprecharge[12] vdd bl[12] bl_n[12] precharge_n SP6TPrecharge
Xprecharge[13] vdd bl[13] bl_n[13] precharge_n SP6TPrecharge
Xprecharge[14] vdd bl[14] bl_n[14] precharge_n SP6TPrecharge
Xprecharge[15] vdd bl[15] bl_n[15] precharge_n SP6TPrecharge
Xprecharge[16] vdd bl[16] bl_n[16] precharge_n SP6TPrecharge
Xprecharge[17] vdd bl[17] bl_n[17] precharge_n SP6TPrecharge
Xprecharge[18] vdd bl[18] bl_n[18] precharge_n SP6TPrecharge
Xprecharge[19] vdd bl[19] bl_n[19] precharge_n SP6TPrecharge
Xprecharge[20] vdd bl[20] bl_n[20] precharge_n SP6TPrecharge
Xprecharge[21] vdd bl[21] bl_n[21] precharge_n SP6TPrecharge
Xprecharge[22] vdd bl[22] bl_n[22] precharge_n SP6TPrecharge
Xprecharge[23] vdd bl[23] bl_n[23] precharge_n SP6TPrecharge
Xprecharge[24] vdd bl[24] bl_n[24] precharge_n SP6TPrecharge
Xprecharge[25] vdd bl[25] bl_n[25] precharge_n SP6TPrecharge
Xprecharge[26] vdd bl[26] bl_n[26] precharge_n SP6TPrecharge
Xprecharge[27] vdd bl[27] bl_n[27] precharge_n SP6TPrecharge
Xprecharge[28] vdd bl[28] bl_n[28] precharge_n SP6TPrecharge
Xprecharge[29] vdd bl[29] bl_n[29] precharge_n SP6TPrecharge
Xprecharge[30] vdd bl[30] bl_n[30] precharge_n SP6TPrecharge
Xprecharge[31] vdd bl[31] bl_n[31] precharge_n SP6TPrecharge
Xcolmux[0] bl[0] bl_n[0] mux[0] bl[1] bl_n[1] mux[1] bl[2] bl_n[2] mux[2] bl[3] bl_n[3] mux[3] vss muxbl[0] muxbl_n[0] SP6TColMux_4C
Xcolmux[1] bl[4] bl_n[4] mux[0] bl[5] bl_n[5] mux[1] bl[6] bl_n[6] mux[2] bl[7] bl_n[7] mux[3] vss muxbl[1] muxbl_n[1] SP6TColMux_4C
Xcolmux[2] bl[8] bl_n[8] mux[0] bl[9] bl_n[9] mux[1] bl[10] bl_n[10] mux[2] bl[11] bl_n[11] mux[3] vss muxbl[2] muxbl_n[2] SP6TColMux_4C
Xcolmux[3] bl[12] bl_n[12] mux[0] bl[13] bl_n[13] mux[1] bl[14] bl_n[14] mux[2] bl[15] bl_n[15] mux[3] vss muxbl[3] muxbl_n[3] SP6TColMux_4C
Xcolmux[4] bl[16] bl_n[16] mux[0] bl[17] bl_n[17] mux[1] bl[18] bl_n[18] mux[2] bl[19] bl_n[19] mux[3] vss muxbl[4] muxbl_n[4] SP6TColMux_4C
Xcolmux[5] bl[20] bl_n[20] mux[0] bl[21] bl_n[21] mux[1] bl[22] bl_n[22] mux[2] bl[23] bl_n[23] mux[3] vss muxbl[5] muxbl_n[5] SP6TColMux_4C
Xcolmux[6] bl[24] bl_n[24] mux[0] bl[25] bl_n[25] mux[1] bl[26] bl_n[26] mux[2] bl[27] bl_n[27] mux[3] vss muxbl[6] muxbl_n[6] SP6TColMux_4C
Xcolmux[7] bl[28] bl_n[28] mux[0] bl[29] bl_n[29] mux[1] bl[30] bl_n[30] mux[2] bl[31] bl_n[31] mux[3] vss muxbl[7] muxbl_n[7] SP6TColMux_4C
Xrw[0] vss vdd d[0] q[0] muxbl[0] muxbl_n[0] intclk we_n SP6TReadWrite_4M
Xrw[1] vss vdd d[1] q[1] muxbl[1] muxbl_n[1] intclk we_n SP6TReadWrite_4M
Xrw[2] vss vdd d[2] q[2] muxbl[2] muxbl_n[2] intclk we_n SP6TReadWrite_4M
Xrw[3] vss vdd d[3] q[3] muxbl[3] muxbl_n[3] intclk we_n SP6TReadWrite_4M
Xrw[4] vss vdd d[4] q[4] muxbl[4] muxbl_n[4] intclk we_n SP6TReadWrite_4M
Xrw[5] vss vdd d[5] q[5] muxbl[5] muxbl_n[5] intclk we_n SP6TReadWrite_4M
Xrw[6] vss vdd d[6] q[6] muxbl[6] muxbl_n[6] intclk we_n SP6TReadWrite_4M
Xrw[7] vss vdd d[7] q[7] muxbl[7] muxbl_n[7] intclk we_n SP6TReadWrite_4M
Xclkwe vss vdd clk intclk we we_en we_n SP6TClockWE
.ends SP6TColumnPeriphery_8B4M

.subckt SP6TColumn_32R8B4M vss vdd wl[0] wl[1] wl[2] wl[3] wl[4] wl[5] wl[6] wl[7] wl[8] wl[9] wl[10] wl[11] wl[12] wl[13] wl[14] wl[15] wl[16] wl[17] wl[18] wl[19] wl[20] wl[21] wl[22] wl[23] wl[24] wl[25] wl[26] wl[27] wl[28] wl[29] wl[30] wl[31] q[0] d[0] q[1] d[1] q[2] d[2] q[3] d[3] q[4] d[4] q[5] d[5] q[6] d[6] q[7] d[7] we clk we_en precharge_n mux[0] mux[1] mux[2] mux[3]
Xarray vss vdd wl[0] wl[1] wl[2] wl[3] wl[4] wl[5] wl[6] wl[7] wl[8] wl[9] wl[10] wl[11] wl[12] wl[13] wl[14] wl[15] wl[16] wl[17] wl[18] wl[19] wl[20] wl[21] wl[22] wl[23] wl[24] wl[25] wl[26] wl[27] wl[28] wl[29] wl[30] wl[31] bl[0] bl_n[0] bl[1] bl_n[1] bl[2] bl_n[2] bl[3] bl_n[3] bl[4] bl_n[4] bl[5] bl_n[5] bl[6] bl_n[6] bl[7] bl_n[7] bl[8] bl_n[8] bl[9] bl_n[9] bl[10] bl_n[10] bl[11] bl_n[11] bl[12] bl_n[12] bl[13] bl_n[13] bl[14] bl_n[14] bl[15] bl_n[15] bl[16] bl_n[16] bl[17] bl_n[17] bl[18] bl_n[18] bl[19] bl_n[19] bl[20] bl_n[20] bl[21] bl_n[21] bl[22] bl_n[22] bl[23] bl_n[23] bl[24] bl_n[24] bl[25] bl_n[25] bl[26] bl_n[26] bl[27] bl_n[27] bl[28] bl_n[28] bl[29] bl_n[29] bl[30] bl_n[30] bl[31] bl_n[31] SP6TArray_32X32BC
Xperiph vss vdd clk precharge_n we we_en q[0] d[0] bl[0] bl_n[0] bl[1] bl_n[1] bl[2] bl_n[2] bl[3] bl_n[3] q[1] d[1] bl[4] bl_n[4] bl[5] bl_n[5] bl[6] bl_n[6] bl[7] bl_n[7] q[2] d[2] bl[8] bl_n[8] bl[9] bl_n[9] bl[10] bl_n[10] bl[11] bl_n[11] q[3] d[3] bl[12] bl_n[12] bl[13] bl_n[13] bl[14] bl_n[14] bl[15] bl_n[15] q[4] d[4] bl[16] bl_n[16] bl[17] bl_n[17] bl[18] bl_n[18] bl[19] bl_n[19] q[5] d[5] bl[20] bl_n[20] bl[21] bl_n[21] bl[22] bl_n[22] bl[23] bl_n[23] q[6] d[6] bl[24] bl_n[24] bl[25] bl_n[25] bl[26] bl_n[26] bl[27] bl_n[27] q[7] d[7] bl[28] bl_n[28] bl[29] bl_n[29] bl[30] bl_n[30] bl[31] bl_n[31] mux[0] mux[1] mux[2] mux[3] SP6TColumnPeriphery_8B4M
.ends SP6TColumn_32R8B4M

.subckt SP6TColumnBlock_32R8B4M1W vss vdd clk precharge_n we_en wl[0] wl[1] wl[2] wl[3] wl[4] wl[5] wl[6] wl[7] wl[8] wl[9] wl[10] wl[11] wl[12] wl[13] wl[14] wl[15] wl[16] wl[17] wl[18] wl[19] wl[20] wl[21] wl[22] wl[23] wl[24] wl[25] wl[26] wl[27] wl[28] wl[29] wl[30] wl[31] mux[0] mux[1] mux[2] mux[3] we[0] q[0] d[0] q[1] d[1] q[2] d[2] q[3] d[3] q[4] d[4] q[5] d[5] q[6] d[6] q[7] d[7]
Xcolumn[0] vss vdd wl[0] wl[1] wl[2] wl[3] wl[4] wl[5] wl[6] wl[7] wl[8] wl[9] wl[10] wl[11] wl[12] wl[13] wl[14] wl[15] wl[16] wl[17] wl[18] wl[19] wl[20] wl[21] wl[22] wl[23] wl[24] wl[25] wl[26] wl[27] wl[28] wl[29] wl[30] wl[31] q[0] d[0] q[1] d[1] q[2] d[2] q[3] d[3] q[4] d[4] q[5] d[5] q[6] d[6] q[7] d[7] we[0] clk we_en precharge_n mux[0] mux[1] mux[2] mux[3] SP6TColumn_32R8B4M
.ends SP6TColumnBlock_32R8B4M1W

.subckt SP6TBlock_128x8_322A1WE clk a[0] a[1] a[2] a[3] a[4] a[5] a[6] vss vdd q[0] q[1] q[2] q[3] q[4] q[5] q[6] q[7] d[0] d[1] d[2] d[3] d[4] d[5] d[6] d[7] we[0]
Xrowperiph vss vdd clk a[0] a[1] a[2] a[3] a[4] a[5] a[6] wl[0] wl[1] wl[2] wl[3] wl[4] wl[5] wl[6] wl[7] wl[8] wl[9] wl[10] wl[11] wl[12] wl[13] wl[14] wl[15] wl[16] wl[17] wl[18] wl[19] wl[20] wl[21] wl[22] wl[23] wl[24] wl[25] wl[26] wl[27] wl[28] wl[29] wl[30] wl[31] mux[0] mux[1] mux[2] mux[3] columnclk precharge_n we_en SP6TRowPeriphery_3_2_2
Xcolumnblock vss vdd columnclk precharge_n we_en wl[0] wl[1] wl[2] wl[3] wl[4] wl[5] wl[6] wl[7] wl[8] wl[9] wl[10] wl[11] wl[12] wl[13] wl[14] wl[15] wl[16] wl[17] wl[18] wl[19] wl[20] wl[21] wl[22] wl[23] wl[24] wl[25] wl[26] wl[27] wl[28] wl[29] wl[30] wl[31] mux[0] mux[1] mux[2] mux[3] we[0] q[0] d[0] q[1] d[1] q[2] d[2] q[3] d[3] q[4] d[4] q[5] d[5] q[6] d[6] q[7] d[7] SP6TColumnBlock_32R8B4M1W
.ends SP6TBlock_128x8_322A1WE

.subckt SP6TTimingIn_7SF vss vdd sr_in sr_out sr_shift sr_latch i[6] i[5] i[4] i[3] i[2] i[1] i[0]
Xshiftff[6] vdd vss sr_in sr_shift i_s[6] dff_x1
Xshiftff[5] vdd vss i_s[6] sr_shift i_s[5] dff_x1
Xshiftff[4] vdd vss i_s[5] sr_shift i_s[4] dff_x1
Xshiftff[3] vdd vss i_s[4] sr_shift i_s[3] dff_x1
Xshiftff[2] vdd vss i_s[3] sr_shift i_s[2] dff_x1
Xshiftff[1] vdd vss i_s[2] sr_shift i_s[1] dff_x1
Xshiftff[0] vdd vss i_s[1] sr_shift sr_out dff_x1
Xlatchff[6] vdd vss i_s[6] sr_latch i[6] dff_x1
Xlatchff[5] vdd vss i_s[5] sr_latch i[5] dff_x1
Xlatchff[4] vdd vss i_s[4] sr_latch i[4] dff_x1
Xlatchff[3] vdd vss i_s[3] sr_latch i[3] dff_x1
Xlatchff[2] vdd vss i_s[2] sr_latch i[2] dff_x1
Xlatchff[1] vdd vss i_s[1] sr_latch i[1] dff_x1
Xlatchff[0] vdd vss sr_out sr_latch i[0] dff_x1
.ends SP6TTimingIn_7SF

.subckt mux2_x1 vdd vss i0 i1 cmd q
Xcmd_inv_nmos cmd_n cmd vss vss sg13_lv_nmos l=1.3e-07 w=7.8e-07
Xcmd_inv_pmos cmd_n cmd vdd vdd sg13_lv_pmos l=1.3e-07 w=7.8e-07
Xi0_nmos vss i0 _net0 vss sg13_lv_nmos l=1.3e-07 w=7.8e-07
Xi0_pmos vdd i0 _net1 vdd sg13_lv_pmos l=1.3e-07 w=7.8e-07
Xcmd_n_npass _net0 cmd_n _q_n vss sg13_lv_nmos l=1.3e-07 w=7.8e-07
Xcmd_ppass _net1 cmd _q_n vdd sg13_lv_pmos l=1.3e-07 w=7.8e-07
Xcmd_npass _q_n cmd _net2 vss sg13_lv_nmos l=1.3e-07 w=7.8e-07
Xcmd_n_ppass _q_n cmd_n _net3 vdd sg13_lv_pmos l=1.3e-07 w=7.8e-07
Xi1_nmos _net2 i1 vss vss sg13_lv_nmos l=1.3e-07 w=7.8e-07
Xi1_pmos _net3 i1 vdd vdd sg13_lv_pmos l=1.3e-07 w=7.8e-07
Xq_n_inv_nmos vss _q_n q vss sg13_lv_nmos l=1.3e-07 w=1.07e-06
Xq_n_inv_pmos vdd _q_n q vdd sg13_lv_pmos l=1.3e-07 w=1.06e-06
.ends mux2_x1

.subckt SP6TTimingOut_2SL vss vdd sr_in sr_out sr_shift sr_latch l2s o[0] o[1]
Xshiftff[0] vdd vss o_m[0] sr_shift o_s[0] dff_x1
Xshiftff[1] vdd vss o_m[1] sr_shift sr_out dff_x1
Xlatchff[0] vdd vss o[0] sr_latch o_l[0] dff_x1
Xlatchff[1] vdd vss o[1] sr_latch o_l[1] dff_x1
Xmux[0] vdd vss sr_in o_l[0] l2s o_m[0] mux2_x1
Xmux[1] vdd vss o_s[0] o_l[1] l2s o_m[1] mux2_x1
.ends SP6TTimingOut_2SL

.subckt SP6TTimingIn_9SL vss vdd sr_in sr_out sr_shift sr_latch i[0] i[1] i[2] i[3] i[4] i[5] i[6] i[7] i[8]
Xshiftff[0] vdd vss sr_in sr_shift i_s[0] dff_x1
Xshiftff[1] vdd vss i_s[0] sr_shift i_s[1] dff_x1
Xshiftff[2] vdd vss i_s[1] sr_shift i_s[2] dff_x1
Xshiftff[3] vdd vss i_s[2] sr_shift i_s[3] dff_x1
Xshiftff[4] vdd vss i_s[3] sr_shift i_s[4] dff_x1
Xshiftff[5] vdd vss i_s[4] sr_shift i_s[5] dff_x1
Xshiftff[6] vdd vss i_s[5] sr_shift i_s[6] dff_x1
Xshiftff[7] vdd vss i_s[6] sr_shift i_s[7] dff_x1
Xshiftff[8] vdd vss i_s[7] sr_shift sr_out dff_x1
Xlatchff[0] vdd vss i_s[0] sr_latch i[0] dff_x1
Xlatchff[1] vdd vss i_s[1] sr_latch i[1] dff_x1
Xlatchff[2] vdd vss i_s[2] sr_latch i[2] dff_x1
Xlatchff[3] vdd vss i_s[3] sr_latch i[3] dff_x1
Xlatchff[4] vdd vss i_s[4] sr_latch i[4] dff_x1
Xlatchff[5] vdd vss i_s[5] sr_latch i[5] dff_x1
Xlatchff[6] vdd vss i_s[6] sr_latch i[6] dff_x1
Xlatchff[7] vdd vss i_s[7] sr_latch i[7] dff_x1
Xlatchff[8] vdd vss sr_out sr_latch i[8] dff_x1
.ends SP6TTimingIn_9SL

.subckt SP6TTimingOut_8SL vss vdd sr_in sr_out sr_shift sr_latch l2s o[0] o[1] o[2] o[3] o[4] o[5] o[6] o[7]
Xshiftff[0] vdd vss o_m[0] sr_shift o_s[0] dff_x1
Xshiftff[1] vdd vss o_m[1] sr_shift o_s[1] dff_x1
Xshiftff[2] vdd vss o_m[2] sr_shift o_s[2] dff_x1
Xshiftff[3] vdd vss o_m[3] sr_shift o_s[3] dff_x1
Xshiftff[4] vdd vss o_m[4] sr_shift o_s[4] dff_x1
Xshiftff[5] vdd vss o_m[5] sr_shift o_s[5] dff_x1
Xshiftff[6] vdd vss o_m[6] sr_shift o_s[6] dff_x1
Xshiftff[7] vdd vss o_m[7] sr_shift sr_out dff_x1
Xlatchff[0] vdd vss o[0] sr_latch o_l[0] dff_x1
Xlatchff[1] vdd vss o[1] sr_latch o_l[1] dff_x1
Xlatchff[2] vdd vss o[2] sr_latch o_l[2] dff_x1
Xlatchff[3] vdd vss o[3] sr_latch o_l[3] dff_x1
Xlatchff[4] vdd vss o[4] sr_latch o_l[4] dff_x1
Xlatchff[5] vdd vss o[5] sr_latch o_l[5] dff_x1
Xlatchff[6] vdd vss o[6] sr_latch o_l[6] dff_x1
Xlatchff[7] vdd vss o[7] sr_latch o_l[7] dff_x1
Xmux[0] vdd vss sr_in o_l[0] l2s o_m[0] mux2_x1
Xmux[1] vdd vss o_s[0] o_l[1] l2s o_m[1] mux2_x1
Xmux[2] vdd vss o_s[1] o_l[2] l2s o_m[2] mux2_x1
Xmux[3] vdd vss o_s[2] o_l[3] l2s o_m[3] mux2_x1
Xmux[4] vdd vss o_s[3] o_l[4] l2s o_m[4] mux2_x1
Xmux[5] vdd vss o_s[4] o_l[5] l2s o_m[5] mux2_x1
Xmux[6] vdd vss o_s[5] o_l[6] l2s o_m[6] mux2_x1
Xmux[7] vdd vss o_s[6] o_l[7] l2s o_m[7] mux2_x1
.ends SP6TTimingOut_8SL

.subckt fill_w2 vdd vss
.ends fill_w2

.subckt SP6TBlock_128x8_322A1WE_Test vss vdd_block vdd_periph clk in_shift in_latch in_srin in_srout out_shift out_latch out_l2s out_srin out_srout
Xblock clk a[0] a[1] a[2] a[3] a[4] a[5] a[6] vss vdd_block q[0] q[1] q[2] q[3] q[4] q[5] q[6] q[7] d[0] d[1] d[2] d[3] d[4] d[5] d[6] d[7] we[0] SP6TBlock_128x8_322A1WE
Xasr vss vdd_periph in_srin in_srconn[0] in_shift in_latch a[6] a[5] a[4] a[3] a[2] a[1] a[0] SP6TTimingIn_7SF
Xclksr vss vdd_periph out_srin out_srconn[0] out_shift clk out_l2s in_latch out_latch SP6TTimingOut_2SL
Xdwesr[0] vss vdd_periph in_srconn[0] in_srout in_shift in_latch d[0] d[1] d[2] d[3] d[4] d[5] d[6] d[7] we[0] SP6TTimingIn_9SL
Xqsr[0] vss vdd_periph out_srconn[0] out_srout out_shift out_latch out_l2s q[0] q[1] q[2] q[3] q[4] q[5] q[6] q[7] SP6TTimingOut_8SL
Xfill[0] vdd_periph vss fill_w2
Xfill[1] vdd_periph vss fill_w2
Xfill[2] vdd_periph vss fill_w2
Xfill[3] vdd_periph vss fill_w2
.ends SP6TBlock_128x8_322A1WE_Test

.subckt SP6TDec_tie_diff_w4 vdd vss
.ends SP6TDec_tie_diff_w4

.subckt PadFrame_SP01 PAD0x0 PAD0x1 PAD0x2 PAD0x3 PAD0x4 PAD0x5 PAD0x6 PAD0x7 PAD0x8 PAD0x9 PAD1x0 PAD1x1 PAD1x2 PAD1x3 PAD1x4 PAD1x5 PAD1x6 PAD1x7 PAD1x8 PAD1x9
XPAD0x0 PAD0x0 BondPad
XPAD0x1 PAD0x1 BondPad
XPAD0x2 PAD0x2 BondPad
XPAD0x3 PAD0x3 BondPad
XPAD0x4 PAD0x4 BondPad
XPAD0x5 PAD0x5 BondPad
XPAD0x6 PAD0x6 BondPad
XPAD0x7 PAD0x7 BondPad
XPAD0x8 PAD0x8 BondPad
XPAD0x9 PAD0x9 BondPad
XPAD1x0 PAD1x0 BondPad
XPAD1x1 PAD1x1 BondPad
XPAD1x2 PAD1x2 BondPad
XPAD1x3 PAD1x3 BondPad
XPAD1x4 PAD1x4 BondPad
XPAD1x5 PAD1x5 BondPad
XPAD1x6 PAD1x6 BondPad
XPAD1x7 PAD1x7 BondPad
XPAD1x8 PAD1x8 BondPad
XPAD1x9 PAD1x9 BondPad
.ends PadFrame_SP01

.subckt SP01 vss vdd_periph vdd_block in_srout out_srout clk out_latch out_shift out_l2s out_srin in_shift in_srin in_latch
Xtestblock vss vdd_block vdd_periph clk in_shift in_latch in_srin in_srout out_shift out_latch out_l2s out_srin out_srout SP6TBlock_128x8_322A1WE_Test
Xpadframe vdd_block vss clk out_shift out_srin in_srin in_latch noconn noconn noconn vdd_periph in_srout out_srout out_latch out_l2s in_shift noconn noconn noconn noconn PadFrame_SP01
.ends SP01

.subckt SP6TRowPredecoders_3_3B vss vdd clk a[0] a[1] a[2] a[3] a[4] a[5] pd[0][0] pd[0][1] pd[0][2] pd[0][3] pd[0][4] pd[0][5] pd[0][6] pd[0][7] page[0] page[1] page[2] page[3] page[4] page[5] page[6] page[7]
Xaff[0] vdd vss a[0] clk aint[0] SP6TDec_dff_x1
Xaff[1] vdd vss a[1] clk aint[1] SP6TDec_dff_x1
Xaff[2] vdd vss a[2] clk aint[2] SP6TDec_dff_x1
Xaff[3] vdd vss a[3] clk aint[3] SP6TDec_dff_x1
Xaff[4] vdd vss a[4] clk aint[4] SP6TDec_dff_x1
Xaff[5] vdd vss a[5] clk aint[5] SP6TDec_dff_x1
Xainv[0] vdd vss aint[0] aint_n[0] SP6TDec_inv_x1
Xainv[1] vdd vss aint[1] aint_n[1] SP6TDec_inv_x1
Xainv[2] vdd vss aint[2] aint_n[2] SP6TDec_inv_x1
Xainv[3] vdd vss aint[3] aint_n[3] SP6TDec_inv_x1
Xainv[4] vdd vss aint[4] aint_n[4] SP6TDec_inv_x1
Xainv[5] vdd vss aint[5] aint_n[5] SP6TDec_inv_x1
Xpd[0]and[0] vdd vss pd[0][0] aint_n[0] aint_n[1] aint_n[2] SP6TDec_and3_x1
Xpd[0]and[1] vdd vss pd[0][1] aint[0] aint_n[1] aint_n[2] SP6TDec_and3_x1
Xpd[0]and[2] vdd vss pd[0][2] aint_n[0] aint[1] aint_n[2] SP6TDec_and3_x1
Xpd[0]and[3] vdd vss pd[0][3] aint[0] aint[1] aint_n[2] SP6TDec_and3_x1
Xpd[0]and[4] vdd vss pd[0][4] aint_n[0] aint_n[1] aint[2] SP6TDec_and3_x1
Xpd[0]and[5] vdd vss pd[0][5] aint[0] aint_n[1] aint[2] SP6TDec_and3_x1
Xpd[0]and[6] vdd vss pd[0][6] aint_n[0] aint[1] aint[2] SP6TDec_and3_x1
Xpd[0]and[7] vdd vss pd[0][7] aint[0] aint[1] aint[2] SP6TDec_and3_x1
Xpage_and[0] vdd vss page[0] aint_n[3] aint_n[4] aint_n[5] SP6TDec_and3_x1
Xpage_and[1] vdd vss page[1] aint[3] aint_n[4] aint_n[5] SP6TDec_and3_x1
Xpage_and[2] vdd vss page[2] aint_n[3] aint[4] aint_n[5] SP6TDec_and3_x1
Xpage_and[3] vdd vss page[3] aint[3] aint[4] aint_n[5] SP6TDec_and3_x1
Xpage_and[4] vdd vss page[4] aint_n[3] aint_n[4] aint[5] SP6TDec_and3_x1
Xpage_and[5] vdd vss page[5] aint[3] aint_n[4] aint[5] SP6TDec_and3_x1
Xpage_and[6] vdd vss page[6] aint_n[3] aint[4] aint[5] SP6TDec_and3_x1
Xpage_and[7] vdd vss page[7] aint[3] aint[4] aint[5] SP6TDec_and3_x1
Xtie[0] vdd vss SP6TDec_tie_diff_w4
Xtie[1] vdd vss SP6TDec_tie_diff_w4
Xtie[2] vdd vss SP6TDec_tie_diff_w4
Xtie[3] vdd vss SP6TDec_tie_diff_w4
Xtie[4] vdd vss SP6TDec_tie_diff_w4
Xtie[5] vdd vss SP6TDec_tie_diff_w4
Xtie[5] vdd vss SP6TDec_tie_diff_w4
Xtie[5] vdd vss SP6TDec_tie_diff_w4
Xtie[5] vdd vss SP6TDec_tie_diff_w4
Xtie[5] vdd vss SP6TDec_tie_diff_w4
Xtie[5] vdd vss SP6TDec_tie_diff_w4
Xtie[5] vdd vss SP6TDec_tie_diff_w4
.ends SP6TRowPredecoders_3_3B

.subckt SP6TRowDecoder_3_3B vss vdd a[0] a[1] a[2] a[3] a[4] a[5] clk wl_en wl[0] wl[1] wl[2] wl[3] wl[4] wl[5] wl[6] wl[7] wl[8] wl[9] wl[10] wl[11] wl[12] wl[13] wl[14] wl[15] wl[16] wl[17] wl[18] wl[19] wl[20] wl[21] wl[22] wl[23] wl[24] wl[25] wl[26] wl[27] wl[28] wl[29] wl[30] wl[31] wl[32] wl[33] wl[34] wl[35] wl[36] wl[37] wl[38] wl[39] wl[40] wl[41] wl[42] wl[43] wl[44] wl[45] wl[46] wl[47] wl[48] wl[49] wl[50] wl[51] wl[52] wl[53] wl[54] wl[55] wl[56] wl[57] wl[58] wl[59] wl[60] wl[61] wl[62] wl[63]
Xpredec vss vdd clk a[0] a[1] a[2] a[3] a[4] a[5] pd[0][0] pd[0][1] pd[0][2] pd[0][3] pd[0][4] pd[0][5] pd[0][6] pd[0][7] page[0] page[1] page[2] page[3] page[4] page[5] page[6] page[7] SP6TRowPredecoders_3_3B
Xpage[0] vss vdd wl[0] wl[1] wl[2] wl[3] wl[4] wl[5] wl[6] wl[7] pd[0][0] pd[0][1] pd[0][2] pd[0][3] pd[0][4] pd[0][5] pd[0][6] pd[0][7] page[0] wl_en SP6TRowDecoderDriverPage_2PD8R
Xpage[1] vss vdd wl[8] wl[9] wl[10] wl[11] wl[12] wl[13] wl[14] wl[15] pd[0][0] pd[0][1] pd[0][2] pd[0][3] pd[0][4] pd[0][5] pd[0][6] pd[0][7] page[1] wl_en SP6TRowDecoderDriverPage_2PD8R
Xpage[2] vss vdd wl[16] wl[17] wl[18] wl[19] wl[20] wl[21] wl[22] wl[23] pd[0][0] pd[0][1] pd[0][2] pd[0][3] pd[0][4] pd[0][5] pd[0][6] pd[0][7] page[2] wl_en SP6TRowDecoderDriverPage_2PD8R
Xpage[3] vss vdd wl[24] wl[25] wl[26] wl[27] wl[28] wl[29] wl[30] wl[31] pd[0][0] pd[0][1] pd[0][2] pd[0][3] pd[0][4] pd[0][5] pd[0][6] pd[0][7] page[3] wl_en SP6TRowDecoderDriverPage_2PD8R
Xpage[4] vss vdd wl[32] wl[33] wl[34] wl[35] wl[36] wl[37] wl[38] wl[39] pd[0][0] pd[0][1] pd[0][2] pd[0][3] pd[0][4] pd[0][5] pd[0][6] pd[0][7] page[4] wl_en SP6TRowDecoderDriverPage_2PD8R
Xpage[5] vss vdd wl[40] wl[41] wl[42] wl[43] wl[44] wl[45] wl[46] wl[47] pd[0][0] pd[0][1] pd[0][2] pd[0][3] pd[0][4] pd[0][5] pd[0][6] pd[0][7] page[5] wl_en SP6TRowDecoderDriverPage_2PD8R
Xpage[6] vss vdd wl[48] wl[49] wl[50] wl[51] wl[52] wl[53] wl[54] wl[55] pd[0][0] pd[0][1] pd[0][2] pd[0][3] pd[0][4] pd[0][5] pd[0][6] pd[0][7] page[6] wl_en SP6TRowDecoderDriverPage_2PD8R
Xpage[7] vss vdd wl[56] wl[57] wl[58] wl[59] wl[60] wl[61] wl[62] wl[63] pd[0][0] pd[0][1] pd[0][2] pd[0][3] pd[0][4] pd[0][5] pd[0][6] pd[0][7] page[7] wl_en SP6TRowDecoderDriverPage_2PD8R
Xbulkcon[0] vdd vss SP6TRowDecoderBulkConn
Xbulkcon[1] vdd vss SP6TRowDecoderBulkConn
Xbulkcon[2] vdd vss SP6TRowDecoderBulkConn
Xbulkcon[3] vdd vss SP6TRowDecoderBulkConn
Xbulkcon[4] vdd vss SP6TRowDecoderBulkConn
.ends SP6TRowDecoder_3_3B

.subckt SP6TRowPeriphery_3_3_2 vss vdd clk a[0] a[1] a[2] a[3] a[4] a[5] a[6] a[7] wl[0] wl[1] wl[2] wl[3] wl[4] wl[5] wl[6] wl[7] wl[8] wl[9] wl[10] wl[11] wl[12] wl[13] wl[14] wl[15] wl[16] wl[17] wl[18] wl[19] wl[20] wl[21] wl[22] wl[23] wl[24] wl[25] wl[26] wl[27] wl[28] wl[29] wl[30] wl[31] wl[32] wl[33] wl[34] wl[35] wl[36] wl[37] wl[38] wl[39] wl[40] wl[41] wl[42] wl[43] wl[44] wl[45] wl[46] wl[47] wl[48] wl[49] wl[50] wl[51] wl[52] wl[53] wl[54] wl[55] wl[56] wl[57] wl[58] wl[59] wl[60] wl[61] wl[62] wl[63] mux[0] mux[1] mux[2] mux[3] columnclk precharge_n we_en
Xclkgen vss vdd clk decodeclk columnclk precharge_n wl_en we_en SP6TClockGenerator_8S1R
Xcoldec vss vdd decodeclk a[0] a[1] mux[0] mux[1] mux[2] mux[3] SP6TLatchedDecoder_2A2R
Xrowdec vss vdd a[2] a[3] a[4] a[5] a[6] a[7] decodeclk wl_en wl[0] wl[1] wl[2] wl[3] wl[4] wl[5] wl[6] wl[7] wl[8] wl[9] wl[10] wl[11] wl[12] wl[13] wl[14] wl[15] wl[16] wl[17] wl[18] wl[19] wl[20] wl[21] wl[22] wl[23] wl[24] wl[25] wl[26] wl[27] wl[28] wl[29] wl[30] wl[31] wl[32] wl[33] wl[34] wl[35] wl[36] wl[37] wl[38] wl[39] wl[40] wl[41] wl[42] wl[43] wl[44] wl[45] wl[46] wl[47] wl[48] wl[49] wl[50] wl[51] wl[52] wl[53] wl[54] wl[55] wl[56] wl[57] wl[58] wl[59] wl[60] wl[61] wl[62] wl[63] SP6TRowDecoder_3_3B
.ends SP6TRowPeriphery_3_3_2

.subckt SP6TArray_32X32 vss vdd wl[0] wl[1] wl[2] wl[3] wl[4] wl[5] wl[6] wl[7] wl[8] wl[9] wl[10] wl[11] wl[12] wl[13] wl[14] wl[15] wl[16] wl[17] wl[18] wl[19] wl[20] wl[21] wl[22] wl[23] wl[24] wl[25] wl[26] wl[27] wl[28] wl[29] wl[30] wl[31] bl[0] bl_n[0] bl[1] bl_n[1] bl[2] bl_n[2] bl[3] bl_n[3] bl[4] bl_n[4] bl[5] bl_n[5] bl[6] bl_n[6] bl[7] bl_n[7] bl[8] bl_n[8] bl[9] bl_n[9] bl[10] bl_n[10] bl[11] bl_n[11] bl[12] bl_n[12] bl[13] bl_n[13] bl[14] bl_n[14] bl[15] bl_n[15] bl[16] bl_n[16] bl[17] bl_n[17] bl[18] bl_n[18] bl[19] bl_n[19] bl[20] bl_n[20] bl[21] bl_n[21] bl[22] bl_n[22] bl[23] bl_n[23] bl[24] bl_n[24] bl[25] bl_n[25] bl[26] bl_n[26] bl[27] bl_n[27] bl[28] bl_n[28] bl[29] bl_n[29] bl[30] bl_n[30] bl[31] bl_n[31]
Xinst0x0 vss vdd wl[0] wl[1] wl[2] wl[3] wl[4] wl[5] wl[6] wl[7] wl[8] wl[9] wl[10] wl[11] wl[12] wl[13] wl[14] wl[15] bl[0] bl_n[0] bl[1] bl_n[1] bl[2] bl_n[2] bl[3] bl_n[3] bl[4] bl_n[4] bl[5] bl_n[5] bl[6] bl_n[6] bl[7] bl_n[7] bl[8] bl_n[8] bl[9] bl_n[9] bl[10] bl_n[10] bl[11] bl_n[11] bl[12] bl_n[12] bl[13] bl_n[13] bl[14] bl_n[14] bl[15] bl_n[15] bl[16] bl_n[16] bl[17] bl_n[17] bl[18] bl_n[18] bl[19] bl_n[19] bl[20] bl_n[20] bl[21] bl_n[21] bl[22] bl_n[22] bl[23] bl_n[23] bl[24] bl_n[24] bl[25] bl_n[25] bl[26] bl_n[26] bl[27] bl_n[27] bl[28] bl_n[28] bl[29] bl_n[29] bl[30] bl_n[30] bl[31] bl_n[31] SP6TArray_16X32
Xinst1x0 vss vdd wl[16] wl[17] wl[18] wl[19] wl[20] wl[21] wl[22] wl[23] wl[24] wl[25] wl[26] wl[27] wl[28] wl[29] wl[30] wl[31] bl[0] bl_n[0] bl[1] bl_n[1] bl[2] bl_n[2] bl[3] bl_n[3] bl[4] bl_n[4] bl[5] bl_n[5] bl[6] bl_n[6] bl[7] bl_n[7] bl[8] bl_n[8] bl[9] bl_n[9] bl[10] bl_n[10] bl[11] bl_n[11] bl[12] bl_n[12] bl[13] bl_n[13] bl[14] bl_n[14] bl[15] bl_n[15] bl[16] bl_n[16] bl[17] bl_n[17] bl[18] bl_n[18] bl[19] bl_n[19] bl[20] bl_n[20] bl[21] bl_n[21] bl[22] bl_n[22] bl[23] bl_n[23] bl[24] bl_n[24] bl[25] bl_n[25] bl[26] bl_n[26] bl[27] bl_n[27] bl[28] bl_n[28] bl[29] bl_n[29] bl[30] bl_n[30] bl[31] bl_n[31] SP6TArray_16X32
Xbcrow vss vdd bl[0] bl_n[0] bl[1] bl_n[1] bl[2] bl_n[2] bl[3] bl_n[3] bl[4] bl_n[4] bl[5] bl_n[5] bl[6] bl_n[6] bl[7] bl_n[7] bl[8] bl_n[8] bl[9] bl_n[9] bl[10] bl_n[10] bl[11] bl_n[11] bl[12] bl_n[12] bl[13] bl_n[13] bl[14] bl_n[14] bl[15] bl_n[15] bl[16] bl_n[16] bl[17] bl_n[17] bl[18] bl_n[18] bl[19] bl_n[19] bl[20] bl_n[20] bl[21] bl_n[21] bl[22] bl_n[22] bl[23] bl_n[23] bl[24] bl_n[24] bl[25] bl_n[25] bl[26] bl_n[26] bl[27] bl_n[27] bl[28] bl_n[28] bl[29] bl_n[29] bl[30] bl_n[30] bl[31] bl_n[31] SP6TBulkConnRow_32
.ends SP6TArray_32X32

.subckt SP6TArray_64X32BC vss vdd wl[0] wl[1] wl[2] wl[3] wl[4] wl[5] wl[6] wl[7] wl[8] wl[9] wl[10] wl[11] wl[12] wl[13] wl[14] wl[15] wl[16] wl[17] wl[18] wl[19] wl[20] wl[21] wl[22] wl[23] wl[24] wl[25] wl[26] wl[27] wl[28] wl[29] wl[30] wl[31] wl[32] wl[33] wl[34] wl[35] wl[36] wl[37] wl[38] wl[39] wl[40] wl[41] wl[42] wl[43] wl[44] wl[45] wl[46] wl[47] wl[48] wl[49] wl[50] wl[51] wl[52] wl[53] wl[54] wl[55] wl[56] wl[57] wl[58] wl[59] wl[60] wl[61] wl[62] wl[63] bl[0] bl_n[0] bl[1] bl_n[1] bl[2] bl_n[2] bl[3] bl_n[3] bl[4] bl_n[4] bl[5] bl_n[5] bl[6] bl_n[6] bl[7] bl_n[7] bl[8] bl_n[8] bl[9] bl_n[9] bl[10] bl_n[10] bl[11] bl_n[11] bl[12] bl_n[12] bl[13] bl_n[13] bl[14] bl_n[14] bl[15] bl_n[15] bl[16] bl_n[16] bl[17] bl_n[17] bl[18] bl_n[18] bl[19] bl_n[19] bl[20] bl_n[20] bl[21] bl_n[21] bl[22] bl_n[22] bl[23] bl_n[23] bl[24] bl_n[24] bl[25] bl_n[25] bl[26] bl_n[26] bl[27] bl_n[27] bl[28] bl_n[28] bl[29] bl_n[29] bl[30] bl_n[30] bl[31] bl_n[31]
Xinst0x0 vss vdd wl[0] wl[1] wl[2] wl[3] wl[4] wl[5] wl[6] wl[7] wl[8] wl[9] wl[10] wl[11] wl[12] wl[13] wl[14] wl[15] wl[16] wl[17] wl[18] wl[19] wl[20] wl[21] wl[22] wl[23] wl[24] wl[25] wl[26] wl[27] wl[28] wl[29] wl[30] wl[31] bl[0] bl_n[0] bl[1] bl_n[1] bl[2] bl_n[2] bl[3] bl_n[3] bl[4] bl_n[4] bl[5] bl_n[5] bl[6] bl_n[6] bl[7] bl_n[7] bl[8] bl_n[8] bl[9] bl_n[9] bl[10] bl_n[10] bl[11] bl_n[11] bl[12] bl_n[12] bl[13] bl_n[13] bl[14] bl_n[14] bl[15] bl_n[15] bl[16] bl_n[16] bl[17] bl_n[17] bl[18] bl_n[18] bl[19] bl_n[19] bl[20] bl_n[20] bl[21] bl_n[21] bl[22] bl_n[22] bl[23] bl_n[23] bl[24] bl_n[24] bl[25] bl_n[25] bl[26] bl_n[26] bl[27] bl_n[27] bl[28] bl_n[28] bl[29] bl_n[29] bl[30] bl_n[30] bl[31] bl_n[31] SP6TArray_32X32
Xinst1x0 vss vdd wl[32] wl[33] wl[34] wl[35] wl[36] wl[37] wl[38] wl[39] wl[40] wl[41] wl[42] wl[43] wl[44] wl[45] wl[46] wl[47] wl[48] wl[49] wl[50] wl[51] wl[52] wl[53] wl[54] wl[55] wl[56] wl[57] wl[58] wl[59] wl[60] wl[61] wl[62] wl[63] bl[0] bl_n[0] bl[1] bl_n[1] bl[2] bl_n[2] bl[3] bl_n[3] bl[4] bl_n[4] bl[5] bl_n[5] bl[6] bl_n[6] bl[7] bl_n[7] bl[8] bl_n[8] bl[9] bl_n[9] bl[10] bl_n[10] bl[11] bl_n[11] bl[12] bl_n[12] bl[13] bl_n[13] bl[14] bl_n[14] bl[15] bl_n[15] bl[16] bl_n[16] bl[17] bl_n[17] bl[18] bl_n[18] bl[19] bl_n[19] bl[20] bl_n[20] bl[21] bl_n[21] bl[22] bl_n[22] bl[23] bl_n[23] bl[24] bl_n[24] bl[25] bl_n[25] bl[26] bl_n[26] bl[27] bl_n[27] bl[28] bl_n[28] bl[29] bl_n[29] bl[30] bl_n[30] bl[31] bl_n[31] SP6TArray_32X32
Xbcrow vss vdd bl[0] bl_n[0] bl[1] bl_n[1] bl[2] bl_n[2] bl[3] bl_n[3] bl[4] bl_n[4] bl[5] bl_n[5] bl[6] bl_n[6] bl[7] bl_n[7] bl[8] bl_n[8] bl[9] bl_n[9] bl[10] bl_n[10] bl[11] bl_n[11] bl[12] bl_n[12] bl[13] bl_n[13] bl[14] bl_n[14] bl[15] bl_n[15] bl[16] bl_n[16] bl[17] bl_n[17] bl[18] bl_n[18] bl[19] bl_n[19] bl[20] bl_n[20] bl[21] bl_n[21] bl[22] bl_n[22] bl[23] bl_n[23] bl[24] bl_n[24] bl[25] bl_n[25] bl[26] bl_n[26] bl[27] bl_n[27] bl[28] bl_n[28] bl[29] bl_n[29] bl[30] bl_n[30] bl[31] bl_n[31] SP6TBulkConnRow_32
Xbottombcrow vss vdd bl[0] bl_n[0] bl[1] bl_n[1] bl[2] bl_n[2] bl[3] bl_n[3] bl[4] bl_n[4] bl[5] bl_n[5] bl[6] bl_n[6] bl[7] bl_n[7] bl[8] bl_n[8] bl[9] bl_n[9] bl[10] bl_n[10] bl[11] bl_n[11] bl[12] bl_n[12] bl[13] bl_n[13] bl[14] bl_n[14] bl[15] bl_n[15] bl[16] bl_n[16] bl[17] bl_n[17] bl[18] bl_n[18] bl[19] bl_n[19] bl[20] bl_n[20] bl[21] bl_n[21] bl[22] bl_n[22] bl[23] bl_n[23] bl[24] bl_n[24] bl[25] bl_n[25] bl[26] bl_n[26] bl[27] bl_n[27] bl[28] bl_n[28] bl[29] bl_n[29] bl[30] bl_n[30] bl[31] bl_n[31] SP6TBulkConnRow_32
Xtopbcrow vss vdd bl[0] bl_n[0] bl[1] bl_n[1] bl[2] bl_n[2] bl[3] bl_n[3] bl[4] bl_n[4] bl[5] bl_n[5] bl[6] bl_n[6] bl[7] bl_n[7] bl[8] bl_n[8] bl[9] bl_n[9] bl[10] bl_n[10] bl[11] bl_n[11] bl[12] bl_n[12] bl[13] bl_n[13] bl[14] bl_n[14] bl[15] bl_n[15] bl[16] bl_n[16] bl[17] bl_n[17] bl[18] bl_n[18] bl[19] bl_n[19] bl[20] bl_n[20] bl[21] bl_n[21] bl[22] bl_n[22] bl[23] bl_n[23] bl[24] bl_n[24] bl[25] bl_n[25] bl[26] bl_n[26] bl[27] bl_n[27] bl[28] bl_n[28] bl[29] bl_n[29] bl[30] bl_n[30] bl[31] bl_n[31] SP6TBulkConnRow_32
.ends SP6TArray_64X32BC

.subckt SP6TColumn_64R8B4M vss vdd wl[0] wl[1] wl[2] wl[3] wl[4] wl[5] wl[6] wl[7] wl[8] wl[9] wl[10] wl[11] wl[12] wl[13] wl[14] wl[15] wl[16] wl[17] wl[18] wl[19] wl[20] wl[21] wl[22] wl[23] wl[24] wl[25] wl[26] wl[27] wl[28] wl[29] wl[30] wl[31] wl[32] wl[33] wl[34] wl[35] wl[36] wl[37] wl[38] wl[39] wl[40] wl[41] wl[42] wl[43] wl[44] wl[45] wl[46] wl[47] wl[48] wl[49] wl[50] wl[51] wl[52] wl[53] wl[54] wl[55] wl[56] wl[57] wl[58] wl[59] wl[60] wl[61] wl[62] wl[63] q[0] d[0] q[1] d[1] q[2] d[2] q[3] d[3] q[4] d[4] q[5] d[5] q[6] d[6] q[7] d[7] we clk we_en precharge_n mux[0] mux[1] mux[2] mux[3]
Xarray vss vdd wl[0] wl[1] wl[2] wl[3] wl[4] wl[5] wl[6] wl[7] wl[8] wl[9] wl[10] wl[11] wl[12] wl[13] wl[14] wl[15] wl[16] wl[17] wl[18] wl[19] wl[20] wl[21] wl[22] wl[23] wl[24] wl[25] wl[26] wl[27] wl[28] wl[29] wl[30] wl[31] wl[32] wl[33] wl[34] wl[35] wl[36] wl[37] wl[38] wl[39] wl[40] wl[41] wl[42] wl[43] wl[44] wl[45] wl[46] wl[47] wl[48] wl[49] wl[50] wl[51] wl[52] wl[53] wl[54] wl[55] wl[56] wl[57] wl[58] wl[59] wl[60] wl[61] wl[62] wl[63] bl[0] bl_n[0] bl[1] bl_n[1] bl[2] bl_n[2] bl[3] bl_n[3] bl[4] bl_n[4] bl[5] bl_n[5] bl[6] bl_n[6] bl[7] bl_n[7] bl[8] bl_n[8] bl[9] bl_n[9] bl[10] bl_n[10] bl[11] bl_n[11] bl[12] bl_n[12] bl[13] bl_n[13] bl[14] bl_n[14] bl[15] bl_n[15] bl[16] bl_n[16] bl[17] bl_n[17] bl[18] bl_n[18] bl[19] bl_n[19] bl[20] bl_n[20] bl[21] bl_n[21] bl[22] bl_n[22] bl[23] bl_n[23] bl[24] bl_n[24] bl[25] bl_n[25] bl[26] bl_n[26] bl[27] bl_n[27] bl[28] bl_n[28] bl[29] bl_n[29] bl[30] bl_n[30] bl[31] bl_n[31] SP6TArray_64X32BC
Xperiph vss vdd clk precharge_n we we_en q[0] d[0] bl[0] bl_n[0] bl[1] bl_n[1] bl[2] bl_n[2] bl[3] bl_n[3] q[1] d[1] bl[4] bl_n[4] bl[5] bl_n[5] bl[6] bl_n[6] bl[7] bl_n[7] q[2] d[2] bl[8] bl_n[8] bl[9] bl_n[9] bl[10] bl_n[10] bl[11] bl_n[11] q[3] d[3] bl[12] bl_n[12] bl[13] bl_n[13] bl[14] bl_n[14] bl[15] bl_n[15] q[4] d[4] bl[16] bl_n[16] bl[17] bl_n[17] bl[18] bl_n[18] bl[19] bl_n[19] q[5] d[5] bl[20] bl_n[20] bl[21] bl_n[21] bl[22] bl_n[22] bl[23] bl_n[23] q[6] d[6] bl[24] bl_n[24] bl[25] bl_n[25] bl[26] bl_n[26] bl[27] bl_n[27] q[7] d[7] bl[28] bl_n[28] bl[29] bl_n[29] bl[30] bl_n[30] bl[31] bl_n[31] mux[0] mux[1] mux[2] mux[3] SP6TColumnPeriphery_8B4M
.ends SP6TColumn_64R8B4M

.subckt SP6TColumnBlock_64R16B4M2W vss vdd clk precharge_n we_en wl[0] wl[1] wl[2] wl[3] wl[4] wl[5] wl[6] wl[7] wl[8] wl[9] wl[10] wl[11] wl[12] wl[13] wl[14] wl[15] wl[16] wl[17] wl[18] wl[19] wl[20] wl[21] wl[22] wl[23] wl[24] wl[25] wl[26] wl[27] wl[28] wl[29] wl[30] wl[31] wl[32] wl[33] wl[34] wl[35] wl[36] wl[37] wl[38] wl[39] wl[40] wl[41] wl[42] wl[43] wl[44] wl[45] wl[46] wl[47] wl[48] wl[49] wl[50] wl[51] wl[52] wl[53] wl[54] wl[55] wl[56] wl[57] wl[58] wl[59] wl[60] wl[61] wl[62] wl[63] mux[0] mux[1] mux[2] mux[3] we[0] q[0] d[0] q[1] d[1] q[2] d[2] q[3] d[3] q[4] d[4] q[5] d[5] q[6] d[6] q[7] d[7] we[1] q[8] d[8] q[9] d[9] q[10] d[10] q[11] d[11] q[12] d[12] q[13] d[13] q[14] d[14] q[15] d[15]
Xcolumn[0] vss vdd wl[0] wl[1] wl[2] wl[3] wl[4] wl[5] wl[6] wl[7] wl[8] wl[9] wl[10] wl[11] wl[12] wl[13] wl[14] wl[15] wl[16] wl[17] wl[18] wl[19] wl[20] wl[21] wl[22] wl[23] wl[24] wl[25] wl[26] wl[27] wl[28] wl[29] wl[30] wl[31] wl[32] wl[33] wl[34] wl[35] wl[36] wl[37] wl[38] wl[39] wl[40] wl[41] wl[42] wl[43] wl[44] wl[45] wl[46] wl[47] wl[48] wl[49] wl[50] wl[51] wl[52] wl[53] wl[54] wl[55] wl[56] wl[57] wl[58] wl[59] wl[60] wl[61] wl[62] wl[63] q[0] d[0] q[1] d[1] q[2] d[2] q[3] d[3] q[4] d[4] q[5] d[5] q[6] d[6] q[7] d[7] we[0] clk we_en precharge_n mux[0] mux[1] mux[2] mux[3] SP6TColumn_64R8B4M
Xcolumn[1] vss vdd wl[0] wl[1] wl[2] wl[3] wl[4] wl[5] wl[6] wl[7] wl[8] wl[9] wl[10] wl[11] wl[12] wl[13] wl[14] wl[15] wl[16] wl[17] wl[18] wl[19] wl[20] wl[21] wl[22] wl[23] wl[24] wl[25] wl[26] wl[27] wl[28] wl[29] wl[30] wl[31] wl[32] wl[33] wl[34] wl[35] wl[36] wl[37] wl[38] wl[39] wl[40] wl[41] wl[42] wl[43] wl[44] wl[45] wl[46] wl[47] wl[48] wl[49] wl[50] wl[51] wl[52] wl[53] wl[54] wl[55] wl[56] wl[57] wl[58] wl[59] wl[60] wl[61] wl[62] wl[63] q[8] d[8] q[9] d[9] q[10] d[10] q[11] d[11] q[12] d[12] q[13] d[13] q[14] d[14] q[15] d[15] we[1] clk we_en precharge_n mux[0] mux[1] mux[2] mux[3] SP6TColumn_64R8B4M
.ends SP6TColumnBlock_64R16B4M2W

.subckt SP6TBlock_256x16_332A2WE clk a[0] a[1] a[2] a[3] a[4] a[5] a[6] a[7] vss vdd q[0] q[1] q[2] q[3] q[4] q[5] q[6] q[7] q[8] q[9] q[10] q[11] q[12] q[13] q[14] q[15] d[0] d[1] d[2] d[3] d[4] d[5] d[6] d[7] d[8] d[9] d[10] d[11] d[12] d[13] d[14] d[15] we[0] we[1]
Xrowperiph vss vdd clk a[0] a[1] a[2] a[3] a[4] a[5] a[6] a[7] wl[0] wl[1] wl[2] wl[3] wl[4] wl[5] wl[6] wl[7] wl[8] wl[9] wl[10] wl[11] wl[12] wl[13] wl[14] wl[15] wl[16] wl[17] wl[18] wl[19] wl[20] wl[21] wl[22] wl[23] wl[24] wl[25] wl[26] wl[27] wl[28] wl[29] wl[30] wl[31] wl[32] wl[33] wl[34] wl[35] wl[36] wl[37] wl[38] wl[39] wl[40] wl[41] wl[42] wl[43] wl[44] wl[45] wl[46] wl[47] wl[48] wl[49] wl[50] wl[51] wl[52] wl[53] wl[54] wl[55] wl[56] wl[57] wl[58] wl[59] wl[60] wl[61] wl[62] wl[63] mux[0] mux[1] mux[2] mux[3] columnclk precharge_n we_en SP6TRowPeriphery_3_3_2
Xcolumnblock vss vdd columnclk precharge_n we_en wl[0] wl[1] wl[2] wl[3] wl[4] wl[5] wl[6] wl[7] wl[8] wl[9] wl[10] wl[11] wl[12] wl[13] wl[14] wl[15] wl[16] wl[17] wl[18] wl[19] wl[20] wl[21] wl[22] wl[23] wl[24] wl[25] wl[26] wl[27] wl[28] wl[29] wl[30] wl[31] wl[32] wl[33] wl[34] wl[35] wl[36] wl[37] wl[38] wl[39] wl[40] wl[41] wl[42] wl[43] wl[44] wl[45] wl[46] wl[47] wl[48] wl[49] wl[50] wl[51] wl[52] wl[53] wl[54] wl[55] wl[56] wl[57] wl[58] wl[59] wl[60] wl[61] wl[62] wl[63] mux[0] mux[1] mux[2] mux[3] we[0] q[0] d[0] q[1] d[1] q[2] d[2] q[3] d[3] q[4] d[4] q[5] d[5] q[6] d[6] q[7] d[7] we[1] q[8] d[8] q[9] d[9] q[10] d[10] q[11] d[11] q[12] d[12] q[13] d[13] q[14] d[14] q[15] d[15] SP6TColumnBlock_64R16B4M2W
.ends SP6TBlock_256x16_332A2WE

.subckt SP6TTimingIn_8SF vss vdd sr_in sr_out sr_shift sr_latch i[7] i[6] i[5] i[4] i[3] i[2] i[1] i[0]
Xshiftff[7] vdd vss sr_in sr_shift i_s[7] dff_x1
Xshiftff[6] vdd vss i_s[7] sr_shift i_s[6] dff_x1
Xshiftff[5] vdd vss i_s[6] sr_shift i_s[5] dff_x1
Xshiftff[4] vdd vss i_s[5] sr_shift i_s[4] dff_x1
Xshiftff[3] vdd vss i_s[4] sr_shift i_s[3] dff_x1
Xshiftff[2] vdd vss i_s[3] sr_shift i_s[2] dff_x1
Xshiftff[1] vdd vss i_s[2] sr_shift i_s[1] dff_x1
Xshiftff[0] vdd vss i_s[1] sr_shift sr_out dff_x1
Xlatchff[7] vdd vss i_s[7] sr_latch i[7] dff_x1
Xlatchff[6] vdd vss i_s[6] sr_latch i[6] dff_x1
Xlatchff[5] vdd vss i_s[5] sr_latch i[5] dff_x1
Xlatchff[4] vdd vss i_s[4] sr_latch i[4] dff_x1
Xlatchff[3] vdd vss i_s[3] sr_latch i[3] dff_x1
Xlatchff[2] vdd vss i_s[2] sr_latch i[2] dff_x1
Xlatchff[1] vdd vss i_s[1] sr_latch i[1] dff_x1
Xlatchff[0] vdd vss sr_out sr_latch i[0] dff_x1
.ends SP6TTimingIn_8SF

.subckt SP6TBlock_256x16_332A2WE_Test vss vdd_block vdd_periph clk in_shift in_latch in_srin in_srout out_shift out_latch out_l2s out_srin out_srout
Xblock clk a[0] a[1] a[2] a[3] a[4] a[5] a[6] a[7] vss vdd_block q[0] q[1] q[2] q[3] q[4] q[5] q[6] q[7] q[8] q[9] q[10] q[11] q[12] q[13] q[14] q[15] d[0] d[1] d[2] d[3] d[4] d[5] d[6] d[7] d[8] d[9] d[10] d[11] d[12] d[13] d[14] d[15] we[0] we[1] SP6TBlock_256x16_332A2WE
Xasr vss vdd_periph in_srin in_srconn[0] in_shift in_latch a[7] a[6] a[5] a[4] a[3] a[2] a[1] a[0] SP6TTimingIn_8SF
Xclksr vss vdd_periph out_srin out_srconn[0] out_shift clk out_l2s in_latch out_latch SP6TTimingOut_2SL
Xdwesr[0] vss vdd_periph in_srconn[0] in_srconn[1] in_shift in_latch d[0] d[1] d[2] d[3] d[4] d[5] d[6] d[7] we[0] SP6TTimingIn_9SL
Xdwesr[1] vss vdd_periph in_srconn[1] in_srout in_shift in_latch d[8] d[9] d[10] d[11] d[12] d[13] d[14] d[15] we[1] SP6TTimingIn_9SL
Xqsr[0] vss vdd_periph out_srconn[0] out_srconn[1] out_shift out_latch out_l2s q[0] q[1] q[2] q[3] q[4] q[5] q[6] q[7] SP6TTimingOut_8SL
Xqsr[1] vss vdd_periph out_srconn[1] out_srout out_shift out_latch out_l2s q[8] q[9] q[10] q[11] q[12] q[13] q[14] q[15] SP6TTimingOut_8SL
Xfill[0] vdd_periph vss fill_w2
Xfill[1] vdd_periph vss fill_w2
Xfill[2] vdd_periph vss fill_w2
Xfill[3] vdd_periph vss fill_w2
.ends SP6TBlock_256x16_332A2WE_Test

.subckt PadFrame_SP02 PAD0x0 PAD0x1 PAD0x2 PAD0x3 PAD0x4 PAD0x5 PAD0x6 PAD0x7 PAD0x8 PAD0x9 PAD1x0 PAD1x1 PAD1x2 PAD1x3 PAD1x4 PAD1x5 PAD1x6 PAD1x7 PAD1x8 PAD1x9
XPAD0x0 PAD0x0 BondPad
XPAD0x1 PAD0x1 BondPad
XPAD0x2 PAD0x2 BondPad
XPAD0x3 PAD0x3 BondPad
XPAD0x4 PAD0x4 BondPad
XPAD0x5 PAD0x5 BondPad
XPAD0x6 PAD0x6 BondPad
XPAD0x7 PAD0x7 BondPad
XPAD0x8 PAD0x8 BondPad
XPAD0x9 PAD0x9 BondPad
XPAD1x0 PAD1x0 BondPad
XPAD1x1 PAD1x1 BondPad
XPAD1x2 PAD1x2 BondPad
XPAD1x3 PAD1x3 BondPad
XPAD1x4 PAD1x4 BondPad
XPAD1x5 PAD1x5 BondPad
XPAD1x6 PAD1x6 BondPad
XPAD1x7 PAD1x7 BondPad
XPAD1x8 PAD1x8 BondPad
XPAD1x9 PAD1x9 BondPad
.ends PadFrame_SP02

.subckt SP02 vss vdd_periph vdd_block in_srout out_srout clk out_latch out_shift out_l2s out_srin in_shift in_srin in_latch
Xtestblock vss vdd_block vdd_periph clk in_shift in_latch in_srin in_srout out_shift out_latch out_l2s out_srin out_srout SP6TBlock_256x16_332A2WE_Test
Xpadframe vdd_block vss clk out_shift out_srin in_srin in_latch noconn noconn noconn vdd_periph in_srout out_srout out_latch out_l2s in_shift noconn noconn noconn noconn PadFrame_SP02
.ends SP02

.subckt SP6TDec_and4_x1 vdd vss q i0 i1 i2 i3
Xi0_nmos nq i0 _net0 vss sg13_lv_nmos l=1.3e-07 w=7.8e-07
Xi0_pmos vdd i0 nq vdd sg13_lv_pmos l=1.3e-07 w=1.2e-06
Xi1_nmos _net0 i1 _net1 vss sg13_lv_nmos l=1.3e-07 w=7.8e-07
Xi1_pmos nq i1 vdd vdd sg13_lv_pmos l=1.3e-07 w=1.2e-06
Xi2_nmos _net1 i2 _net2 vss sg13_lv_nmos l=1.3e-07 w=7.8e-07
Xi2_pmos vdd i2 nq vdd sg13_lv_pmos l=1.3e-07 w=1.2e-06
Xi3_nmos _net2 i3 vss vss sg13_lv_nmos l=1.3e-07 w=7.8e-07
Xi3_pmos nq i3 vdd vdd sg13_lv_pmos l=1.3e-07 w=1.2e-06
Xn_pd vss nq q vss sg13_lv_nmos l=1.3e-07 w=2.8e-06
Xq_pu vdd nq q vdd sg13_lv_pmos l=1.3e-07 w=4.4e-06
.ends SP6TDec_and4_x1

.subckt SP6TRowPredecoders_3_4B vss vdd clk a[0] a[1] a[2] a[3] a[4] a[5] a[6] pd[0][0] pd[0][1] pd[0][2] pd[0][3] pd[0][4] pd[0][5] pd[0][6] pd[0][7] page[0] page[1] page[2] page[3] page[4] page[5] page[6] page[7] page[8] page[9] page[10] page[11] page[12] page[13] page[14] page[15]
Xaff[0] vdd vss a[0] clk aint[0] SP6TDec_dff_x1
Xaff[1] vdd vss a[1] clk aint[1] SP6TDec_dff_x1
Xaff[2] vdd vss a[2] clk aint[2] SP6TDec_dff_x1
Xaff[3] vdd vss a[3] clk aint[3] SP6TDec_dff_x1
Xaff[4] vdd vss a[4] clk aint[4] SP6TDec_dff_x1
Xaff[5] vdd vss a[5] clk aint[5] SP6TDec_dff_x1
Xaff[6] vdd vss a[6] clk aint[6] SP6TDec_dff_x1
Xainv[0] vdd vss aint[0] aint_n[0] SP6TDec_inv_x1
Xainv[1] vdd vss aint[1] aint_n[1] SP6TDec_inv_x1
Xainv[2] vdd vss aint[2] aint_n[2] SP6TDec_inv_x1
Xainv[3] vdd vss aint[3] aint_n[3] SP6TDec_inv_x1
Xainv[4] vdd vss aint[4] aint_n[4] SP6TDec_inv_x1
Xainv[5] vdd vss aint[5] aint_n[5] SP6TDec_inv_x1
Xainv[6] vdd vss aint[6] aint_n[6] SP6TDec_inv_x1
Xpd[0]and[0] vdd vss pd[0][0] aint_n[0] aint_n[1] aint_n[2] SP6TDec_and3_x1
Xpd[0]and[1] vdd vss pd[0][1] aint[0] aint_n[1] aint_n[2] SP6TDec_and3_x1
Xpd[0]and[2] vdd vss pd[0][2] aint_n[0] aint[1] aint_n[2] SP6TDec_and3_x1
Xpd[0]and[3] vdd vss pd[0][3] aint[0] aint[1] aint_n[2] SP6TDec_and3_x1
Xpd[0]and[4] vdd vss pd[0][4] aint_n[0] aint_n[1] aint[2] SP6TDec_and3_x1
Xpd[0]and[5] vdd vss pd[0][5] aint[0] aint_n[1] aint[2] SP6TDec_and3_x1
Xpd[0]and[6] vdd vss pd[0][6] aint_n[0] aint[1] aint[2] SP6TDec_and3_x1
Xpd[0]and[7] vdd vss pd[0][7] aint[0] aint[1] aint[2] SP6TDec_and3_x1
Xpage_and[0] vdd vss page[0] aint_n[3] aint_n[4] aint_n[5] aint_n[6] SP6TDec_and4_x1
Xpage_and[1] vdd vss page[1] aint[3] aint_n[4] aint_n[5] aint_n[6] SP6TDec_and4_x1
Xpage_and[2] vdd vss page[2] aint_n[3] aint[4] aint_n[5] aint_n[6] SP6TDec_and4_x1
Xpage_and[3] vdd vss page[3] aint[3] aint[4] aint_n[5] aint_n[6] SP6TDec_and4_x1
Xpage_and[4] vdd vss page[4] aint_n[3] aint_n[4] aint[5] aint_n[6] SP6TDec_and4_x1
Xpage_and[5] vdd vss page[5] aint[3] aint_n[4] aint[5] aint_n[6] SP6TDec_and4_x1
Xpage_and[6] vdd vss page[6] aint_n[3] aint[4] aint[5] aint_n[6] SP6TDec_and4_x1
Xpage_and[7] vdd vss page[7] aint[3] aint[4] aint[5] aint_n[6] SP6TDec_and4_x1
Xpage_and[8] vdd vss page[8] aint_n[3] aint_n[4] aint_n[5] aint[6] SP6TDec_and4_x1
Xpage_and[9] vdd vss page[9] aint[3] aint_n[4] aint_n[5] aint[6] SP6TDec_and4_x1
Xpage_and[10] vdd vss page[10] aint_n[3] aint[4] aint_n[5] aint[6] SP6TDec_and4_x1
Xpage_and[11] vdd vss page[11] aint[3] aint[4] aint_n[5] aint[6] SP6TDec_and4_x1
Xpage_and[12] vdd vss page[12] aint_n[3] aint_n[4] aint[5] aint[6] SP6TDec_and4_x1
Xpage_and[13] vdd vss page[13] aint[3] aint_n[4] aint[5] aint[6] SP6TDec_and4_x1
Xpage_and[14] vdd vss page[14] aint_n[3] aint[4] aint[5] aint[6] SP6TDec_and4_x1
Xpage_and[15] vdd vss page[15] aint[3] aint[4] aint[5] aint[6] SP6TDec_and4_x1
Xtie[0] vdd vss SP6TDec_tie_diff_w4
Xtie[1] vdd vss SP6TDec_tie_diff_w4
Xtie[2] vdd vss SP6TDec_tie_diff_w4
Xtie[3] vdd vss SP6TDec_tie_diff_w4
Xtie[4] vdd vss SP6TDec_tie_diff_w4
Xtie[5] vdd vss SP6TDec_tie_diff_w4
Xtie[6] vdd vss SP6TDec_tie_diff_w4
Xtie[7] vdd vss SP6TDec_tie_diff_w4
Xtie[8] vdd vss SP6TDec_tie_diff_w4
Xtie[9] vdd vss SP6TDec_tie_diff_w4
Xtie[10] vdd vss SP6TDec_tie_diff_w4
Xtie[11] vdd vss SP6TDec_tie_diff_w4
Xtie[12] vdd vss SP6TDec_tie_diff_w4
Xtie[13] vdd vss SP6TDec_tie_diff_w4
Xtie[14] vdd vss SP6TDec_tie_diff_w4
Xtie[15] vdd vss SP6TDec_tie_diff_w4
Xtie[16] vdd vss SP6TDec_tie_diff_w4
Xtie[17] vdd vss SP6TDec_tie_diff_w4
Xtie[18] vdd vss SP6TDec_tie_diff_w4
Xtie[19] vdd vss SP6TDec_tie_diff_w4
Xtie[20] vdd vss SP6TDec_tie_diff_w4
Xtie[21] vdd vss SP6TDec_tie_diff_w4
Xtie[22] vdd vss SP6TDec_tie_diff_w4
Xtie[23] vdd vss SP6TDec_tie_diff_w4
Xtie[24] vdd vss SP6TDec_tie_diff_w4
Xtie[24] vdd vss SP6TDec_tie_diff_w4
Xtie[24] vdd vss SP6TDec_tie_diff_w4
Xtie[24] vdd vss SP6TDec_tie_diff_w4
Xtie[24] vdd vss SP6TDec_tie_diff_w4
Xtie[24] vdd vss SP6TDec_tie_diff_w4
Xtie[24] vdd vss SP6TDec_tie_diff_w4
Xtie[24] vdd vss SP6TDec_tie_diff_w4
Xtie[24] vdd vss SP6TDec_tie_diff_w4
Xtie[24] vdd vss SP6TDec_tie_diff_w4
Xtie[24] vdd vss SP6TDec_tie_diff_w4
Xtie[24] vdd vss SP6TDec_tie_diff_w4
Xtie[24] vdd vss SP6TDec_tie_diff_w4
Xtie[24] vdd vss SP6TDec_tie_diff_w4
Xtie[24] vdd vss SP6TDec_tie_diff_w4
Xtie[24] vdd vss SP6TDec_tie_diff_w4
Xtie[24] vdd vss SP6TDec_tie_diff_w4
Xtie[24] vdd vss SP6TDec_tie_diff_w4
Xtie[24] vdd vss SP6TDec_tie_diff_w4
Xtie[24] vdd vss SP6TDec_tie_diff_w4
Xtie[24] vdd vss SP6TDec_tie_diff_w4
.ends SP6TRowPredecoders_3_4B

.subckt SP6TRowDecoder_3_4B vss vdd a[0] a[1] a[2] a[3] a[4] a[5] a[6] clk wl_en wl[0] wl[1] wl[2] wl[3] wl[4] wl[5] wl[6] wl[7] wl[8] wl[9] wl[10] wl[11] wl[12] wl[13] wl[14] wl[15] wl[16] wl[17] wl[18] wl[19] wl[20] wl[21] wl[22] wl[23] wl[24] wl[25] wl[26] wl[27] wl[28] wl[29] wl[30] wl[31] wl[32] wl[33] wl[34] wl[35] wl[36] wl[37] wl[38] wl[39] wl[40] wl[41] wl[42] wl[43] wl[44] wl[45] wl[46] wl[47] wl[48] wl[49] wl[50] wl[51] wl[52] wl[53] wl[54] wl[55] wl[56] wl[57] wl[58] wl[59] wl[60] wl[61] wl[62] wl[63] wl[64] wl[65] wl[66] wl[67] wl[68] wl[69] wl[70] wl[71] wl[72] wl[73] wl[74] wl[75] wl[76] wl[77] wl[78] wl[79] wl[80] wl[81] wl[82] wl[83] wl[84] wl[85] wl[86] wl[87] wl[88] wl[89] wl[90] wl[91] wl[92] wl[93] wl[94] wl[95] wl[96] wl[97] wl[98] wl[99] wl[100] wl[101] wl[102] wl[103] wl[104] wl[105] wl[106] wl[107] wl[108] wl[109] wl[110] wl[111] wl[112] wl[113] wl[114] wl[115] wl[116] wl[117] wl[118] wl[119] wl[120] wl[121] wl[122] wl[123] wl[124] wl[125] wl[126] wl[127]
Xpredec vss vdd clk a[0] a[1] a[2] a[3] a[4] a[5] a[6] pd[0][0] pd[0][1] pd[0][2] pd[0][3] pd[0][4] pd[0][5] pd[0][6] pd[0][7] page[0] page[1] page[2] page[3] page[4] page[5] page[6] page[7] page[8] page[9] page[10] page[11] page[12] page[13] page[14] page[15] SP6TRowPredecoders_3_4B
Xpage[0] vss vdd wl[0] wl[1] wl[2] wl[3] wl[4] wl[5] wl[6] wl[7] pd[0][0] pd[0][1] pd[0][2] pd[0][3] pd[0][4] pd[0][5] pd[0][6] pd[0][7] page[0] wl_en SP6TRowDecoderDriverPage_2PD8R
Xpage[1] vss vdd wl[8] wl[9] wl[10] wl[11] wl[12] wl[13] wl[14] wl[15] pd[0][0] pd[0][1] pd[0][2] pd[0][3] pd[0][4] pd[0][5] pd[0][6] pd[0][7] page[1] wl_en SP6TRowDecoderDriverPage_2PD8R
Xpage[2] vss vdd wl[16] wl[17] wl[18] wl[19] wl[20] wl[21] wl[22] wl[23] pd[0][0] pd[0][1] pd[0][2] pd[0][3] pd[0][4] pd[0][5] pd[0][6] pd[0][7] page[2] wl_en SP6TRowDecoderDriverPage_2PD8R
Xpage[3] vss vdd wl[24] wl[25] wl[26] wl[27] wl[28] wl[29] wl[30] wl[31] pd[0][0] pd[0][1] pd[0][2] pd[0][3] pd[0][4] pd[0][5] pd[0][6] pd[0][7] page[3] wl_en SP6TRowDecoderDriverPage_2PD8R
Xpage[4] vss vdd wl[32] wl[33] wl[34] wl[35] wl[36] wl[37] wl[38] wl[39] pd[0][0] pd[0][1] pd[0][2] pd[0][3] pd[0][4] pd[0][5] pd[0][6] pd[0][7] page[4] wl_en SP6TRowDecoderDriverPage_2PD8R
Xpage[5] vss vdd wl[40] wl[41] wl[42] wl[43] wl[44] wl[45] wl[46] wl[47] pd[0][0] pd[0][1] pd[0][2] pd[0][3] pd[0][4] pd[0][5] pd[0][6] pd[0][7] page[5] wl_en SP6TRowDecoderDriverPage_2PD8R
Xpage[6] vss vdd wl[48] wl[49] wl[50] wl[51] wl[52] wl[53] wl[54] wl[55] pd[0][0] pd[0][1] pd[0][2] pd[0][3] pd[0][4] pd[0][5] pd[0][6] pd[0][7] page[6] wl_en SP6TRowDecoderDriverPage_2PD8R
Xpage[7] vss vdd wl[56] wl[57] wl[58] wl[59] wl[60] wl[61] wl[62] wl[63] pd[0][0] pd[0][1] pd[0][2] pd[0][3] pd[0][4] pd[0][5] pd[0][6] pd[0][7] page[7] wl_en SP6TRowDecoderDriverPage_2PD8R
Xpage[8] vss vdd wl[64] wl[65] wl[66] wl[67] wl[68] wl[69] wl[70] wl[71] pd[0][0] pd[0][1] pd[0][2] pd[0][3] pd[0][4] pd[0][5] pd[0][6] pd[0][7] page[8] wl_en SP6TRowDecoderDriverPage_2PD8R
Xpage[9] vss vdd wl[72] wl[73] wl[74] wl[75] wl[76] wl[77] wl[78] wl[79] pd[0][0] pd[0][1] pd[0][2] pd[0][3] pd[0][4] pd[0][5] pd[0][6] pd[0][7] page[9] wl_en SP6TRowDecoderDriverPage_2PD8R
Xpage[10] vss vdd wl[80] wl[81] wl[82] wl[83] wl[84] wl[85] wl[86] wl[87] pd[0][0] pd[0][1] pd[0][2] pd[0][3] pd[0][4] pd[0][5] pd[0][6] pd[0][7] page[10] wl_en SP6TRowDecoderDriverPage_2PD8R
Xpage[11] vss vdd wl[88] wl[89] wl[90] wl[91] wl[92] wl[93] wl[94] wl[95] pd[0][0] pd[0][1] pd[0][2] pd[0][3] pd[0][4] pd[0][5] pd[0][6] pd[0][7] page[11] wl_en SP6TRowDecoderDriverPage_2PD8R
Xpage[12] vss vdd wl[96] wl[97] wl[98] wl[99] wl[100] wl[101] wl[102] wl[103] pd[0][0] pd[0][1] pd[0][2] pd[0][3] pd[0][4] pd[0][5] pd[0][6] pd[0][7] page[12] wl_en SP6TRowDecoderDriverPage_2PD8R
Xpage[13] vss vdd wl[104] wl[105] wl[106] wl[107] wl[108] wl[109] wl[110] wl[111] pd[0][0] pd[0][1] pd[0][2] pd[0][3] pd[0][4] pd[0][5] pd[0][6] pd[0][7] page[13] wl_en SP6TRowDecoderDriverPage_2PD8R
Xpage[14] vss vdd wl[112] wl[113] wl[114] wl[115] wl[116] wl[117] wl[118] wl[119] pd[0][0] pd[0][1] pd[0][2] pd[0][3] pd[0][4] pd[0][5] pd[0][6] pd[0][7] page[14] wl_en SP6TRowDecoderDriverPage_2PD8R
Xpage[15] vss vdd wl[120] wl[121] wl[122] wl[123] wl[124] wl[125] wl[126] wl[127] pd[0][0] pd[0][1] pd[0][2] pd[0][3] pd[0][4] pd[0][5] pd[0][6] pd[0][7] page[15] wl_en SP6TRowDecoderDriverPage_2PD8R
Xbulkcon[0] vdd vss SP6TRowDecoderBulkConn
Xbulkcon[1] vdd vss SP6TRowDecoderBulkConn
Xbulkcon[2] vdd vss SP6TRowDecoderBulkConn
Xbulkcon[3] vdd vss SP6TRowDecoderBulkConn
Xbulkcon[4] vdd vss SP6TRowDecoderBulkConn
Xbulkcon[5] vdd vss SP6TRowDecoderBulkConn
Xbulkcon[6] vdd vss SP6TRowDecoderBulkConn
Xbulkcon[7] vdd vss SP6TRowDecoderBulkConn
Xbulkcon[8] vdd vss SP6TRowDecoderBulkConn
.ends SP6TRowDecoder_3_4B

.subckt SP6TRowPeriphery_3_4_2 vss vdd clk a[0] a[1] a[2] a[3] a[4] a[5] a[6] a[7] a[8] wl[0] wl[1] wl[2] wl[3] wl[4] wl[5] wl[6] wl[7] wl[8] wl[9] wl[10] wl[11] wl[12] wl[13] wl[14] wl[15] wl[16] wl[17] wl[18] wl[19] wl[20] wl[21] wl[22] wl[23] wl[24] wl[25] wl[26] wl[27] wl[28] wl[29] wl[30] wl[31] wl[32] wl[33] wl[34] wl[35] wl[36] wl[37] wl[38] wl[39] wl[40] wl[41] wl[42] wl[43] wl[44] wl[45] wl[46] wl[47] wl[48] wl[49] wl[50] wl[51] wl[52] wl[53] wl[54] wl[55] wl[56] wl[57] wl[58] wl[59] wl[60] wl[61] wl[62] wl[63] wl[64] wl[65] wl[66] wl[67] wl[68] wl[69] wl[70] wl[71] wl[72] wl[73] wl[74] wl[75] wl[76] wl[77] wl[78] wl[79] wl[80] wl[81] wl[82] wl[83] wl[84] wl[85] wl[86] wl[87] wl[88] wl[89] wl[90] wl[91] wl[92] wl[93] wl[94] wl[95] wl[96] wl[97] wl[98] wl[99] wl[100] wl[101] wl[102] wl[103] wl[104] wl[105] wl[106] wl[107] wl[108] wl[109] wl[110] wl[111] wl[112] wl[113] wl[114] wl[115] wl[116] wl[117] wl[118] wl[119] wl[120] wl[121] wl[122] wl[123] wl[124] wl[125] wl[126] wl[127] mux[0] mux[1] mux[2] mux[3] columnclk precharge_n we_en
Xclkgen vss vdd clk decodeclk columnclk precharge_n wl_en we_en SP6TClockGenerator_8S1R
Xcoldec vss vdd decodeclk a[0] a[1] mux[0] mux[1] mux[2] mux[3] SP6TLatchedDecoder_2A2R
Xrowdec vss vdd a[2] a[3] a[4] a[5] a[6] a[7] a[8] decodeclk wl_en wl[0] wl[1] wl[2] wl[3] wl[4] wl[5] wl[6] wl[7] wl[8] wl[9] wl[10] wl[11] wl[12] wl[13] wl[14] wl[15] wl[16] wl[17] wl[18] wl[19] wl[20] wl[21] wl[22] wl[23] wl[24] wl[25] wl[26] wl[27] wl[28] wl[29] wl[30] wl[31] wl[32] wl[33] wl[34] wl[35] wl[36] wl[37] wl[38] wl[39] wl[40] wl[41] wl[42] wl[43] wl[44] wl[45] wl[46] wl[47] wl[48] wl[49] wl[50] wl[51] wl[52] wl[53] wl[54] wl[55] wl[56] wl[57] wl[58] wl[59] wl[60] wl[61] wl[62] wl[63] wl[64] wl[65] wl[66] wl[67] wl[68] wl[69] wl[70] wl[71] wl[72] wl[73] wl[74] wl[75] wl[76] wl[77] wl[78] wl[79] wl[80] wl[81] wl[82] wl[83] wl[84] wl[85] wl[86] wl[87] wl[88] wl[89] wl[90] wl[91] wl[92] wl[93] wl[94] wl[95] wl[96] wl[97] wl[98] wl[99] wl[100] wl[101] wl[102] wl[103] wl[104] wl[105] wl[106] wl[107] wl[108] wl[109] wl[110] wl[111] wl[112] wl[113] wl[114] wl[115] wl[116] wl[117] wl[118] wl[119] wl[120] wl[121] wl[122] wl[123] wl[124] wl[125] wl[126] wl[127] SP6TRowDecoder_3_4B
.ends SP6TRowPeriphery_3_4_2

.subckt SP6TArray_64X32 vss vdd wl[0] wl[1] wl[2] wl[3] wl[4] wl[5] wl[6] wl[7] wl[8] wl[9] wl[10] wl[11] wl[12] wl[13] wl[14] wl[15] wl[16] wl[17] wl[18] wl[19] wl[20] wl[21] wl[22] wl[23] wl[24] wl[25] wl[26] wl[27] wl[28] wl[29] wl[30] wl[31] wl[32] wl[33] wl[34] wl[35] wl[36] wl[37] wl[38] wl[39] wl[40] wl[41] wl[42] wl[43] wl[44] wl[45] wl[46] wl[47] wl[48] wl[49] wl[50] wl[51] wl[52] wl[53] wl[54] wl[55] wl[56] wl[57] wl[58] wl[59] wl[60] wl[61] wl[62] wl[63] bl[0] bl_n[0] bl[1] bl_n[1] bl[2] bl_n[2] bl[3] bl_n[3] bl[4] bl_n[4] bl[5] bl_n[5] bl[6] bl_n[6] bl[7] bl_n[7] bl[8] bl_n[8] bl[9] bl_n[9] bl[10] bl_n[10] bl[11] bl_n[11] bl[12] bl_n[12] bl[13] bl_n[13] bl[14] bl_n[14] bl[15] bl_n[15] bl[16] bl_n[16] bl[17] bl_n[17] bl[18] bl_n[18] bl[19] bl_n[19] bl[20] bl_n[20] bl[21] bl_n[21] bl[22] bl_n[22] bl[23] bl_n[23] bl[24] bl_n[24] bl[25] bl_n[25] bl[26] bl_n[26] bl[27] bl_n[27] bl[28] bl_n[28] bl[29] bl_n[29] bl[30] bl_n[30] bl[31] bl_n[31]
Xinst0x0 vss vdd wl[0] wl[1] wl[2] wl[3] wl[4] wl[5] wl[6] wl[7] wl[8] wl[9] wl[10] wl[11] wl[12] wl[13] wl[14] wl[15] wl[16] wl[17] wl[18] wl[19] wl[20] wl[21] wl[22] wl[23] wl[24] wl[25] wl[26] wl[27] wl[28] wl[29] wl[30] wl[31] bl[0] bl_n[0] bl[1] bl_n[1] bl[2] bl_n[2] bl[3] bl_n[3] bl[4] bl_n[4] bl[5] bl_n[5] bl[6] bl_n[6] bl[7] bl_n[7] bl[8] bl_n[8] bl[9] bl_n[9] bl[10] bl_n[10] bl[11] bl_n[11] bl[12] bl_n[12] bl[13] bl_n[13] bl[14] bl_n[14] bl[15] bl_n[15] bl[16] bl_n[16] bl[17] bl_n[17] bl[18] bl_n[18] bl[19] bl_n[19] bl[20] bl_n[20] bl[21] bl_n[21] bl[22] bl_n[22] bl[23] bl_n[23] bl[24] bl_n[24] bl[25] bl_n[25] bl[26] bl_n[26] bl[27] bl_n[27] bl[28] bl_n[28] bl[29] bl_n[29] bl[30] bl_n[30] bl[31] bl_n[31] SP6TArray_32X32
Xinst1x0 vss vdd wl[32] wl[33] wl[34] wl[35] wl[36] wl[37] wl[38] wl[39] wl[40] wl[41] wl[42] wl[43] wl[44] wl[45] wl[46] wl[47] wl[48] wl[49] wl[50] wl[51] wl[52] wl[53] wl[54] wl[55] wl[56] wl[57] wl[58] wl[59] wl[60] wl[61] wl[62] wl[63] bl[0] bl_n[0] bl[1] bl_n[1] bl[2] bl_n[2] bl[3] bl_n[3] bl[4] bl_n[4] bl[5] bl_n[5] bl[6] bl_n[6] bl[7] bl_n[7] bl[8] bl_n[8] bl[9] bl_n[9] bl[10] bl_n[10] bl[11] bl_n[11] bl[12] bl_n[12] bl[13] bl_n[13] bl[14] bl_n[14] bl[15] bl_n[15] bl[16] bl_n[16] bl[17] bl_n[17] bl[18] bl_n[18] bl[19] bl_n[19] bl[20] bl_n[20] bl[21] bl_n[21] bl[22] bl_n[22] bl[23] bl_n[23] bl[24] bl_n[24] bl[25] bl_n[25] bl[26] bl_n[26] bl[27] bl_n[27] bl[28] bl_n[28] bl[29] bl_n[29] bl[30] bl_n[30] bl[31] bl_n[31] SP6TArray_32X32
Xbcrow vss vdd bl[0] bl_n[0] bl[1] bl_n[1] bl[2] bl_n[2] bl[3] bl_n[3] bl[4] bl_n[4] bl[5] bl_n[5] bl[6] bl_n[6] bl[7] bl_n[7] bl[8] bl_n[8] bl[9] bl_n[9] bl[10] bl_n[10] bl[11] bl_n[11] bl[12] bl_n[12] bl[13] bl_n[13] bl[14] bl_n[14] bl[15] bl_n[15] bl[16] bl_n[16] bl[17] bl_n[17] bl[18] bl_n[18] bl[19] bl_n[19] bl[20] bl_n[20] bl[21] bl_n[21] bl[22] bl_n[22] bl[23] bl_n[23] bl[24] bl_n[24] bl[25] bl_n[25] bl[26] bl_n[26] bl[27] bl_n[27] bl[28] bl_n[28] bl[29] bl_n[29] bl[30] bl_n[30] bl[31] bl_n[31] SP6TBulkConnRow_32
.ends SP6TArray_64X32

.subckt SP6TArray_128X32BC vss vdd wl[0] wl[1] wl[2] wl[3] wl[4] wl[5] wl[6] wl[7] wl[8] wl[9] wl[10] wl[11] wl[12] wl[13] wl[14] wl[15] wl[16] wl[17] wl[18] wl[19] wl[20] wl[21] wl[22] wl[23] wl[24] wl[25] wl[26] wl[27] wl[28] wl[29] wl[30] wl[31] wl[32] wl[33] wl[34] wl[35] wl[36] wl[37] wl[38] wl[39] wl[40] wl[41] wl[42] wl[43] wl[44] wl[45] wl[46] wl[47] wl[48] wl[49] wl[50] wl[51] wl[52] wl[53] wl[54] wl[55] wl[56] wl[57] wl[58] wl[59] wl[60] wl[61] wl[62] wl[63] wl[64] wl[65] wl[66] wl[67] wl[68] wl[69] wl[70] wl[71] wl[72] wl[73] wl[74] wl[75] wl[76] wl[77] wl[78] wl[79] wl[80] wl[81] wl[82] wl[83] wl[84] wl[85] wl[86] wl[87] wl[88] wl[89] wl[90] wl[91] wl[92] wl[93] wl[94] wl[95] wl[96] wl[97] wl[98] wl[99] wl[100] wl[101] wl[102] wl[103] wl[104] wl[105] wl[106] wl[107] wl[108] wl[109] wl[110] wl[111] wl[112] wl[113] wl[114] wl[115] wl[116] wl[117] wl[118] wl[119] wl[120] wl[121] wl[122] wl[123] wl[124] wl[125] wl[126] wl[127] bl[0] bl_n[0] bl[1] bl_n[1] bl[2] bl_n[2] bl[3] bl_n[3] bl[4] bl_n[4] bl[5] bl_n[5] bl[6] bl_n[6] bl[7] bl_n[7] bl[8] bl_n[8] bl[9] bl_n[9] bl[10] bl_n[10] bl[11] bl_n[11] bl[12] bl_n[12] bl[13] bl_n[13] bl[14] bl_n[14] bl[15] bl_n[15] bl[16] bl_n[16] bl[17] bl_n[17] bl[18] bl_n[18] bl[19] bl_n[19] bl[20] bl_n[20] bl[21] bl_n[21] bl[22] bl_n[22] bl[23] bl_n[23] bl[24] bl_n[24] bl[25] bl_n[25] bl[26] bl_n[26] bl[27] bl_n[27] bl[28] bl_n[28] bl[29] bl_n[29] bl[30] bl_n[30] bl[31] bl_n[31]
Xinst0x0 vss vdd wl[0] wl[1] wl[2] wl[3] wl[4] wl[5] wl[6] wl[7] wl[8] wl[9] wl[10] wl[11] wl[12] wl[13] wl[14] wl[15] wl[16] wl[17] wl[18] wl[19] wl[20] wl[21] wl[22] wl[23] wl[24] wl[25] wl[26] wl[27] wl[28] wl[29] wl[30] wl[31] wl[32] wl[33] wl[34] wl[35] wl[36] wl[37] wl[38] wl[39] wl[40] wl[41] wl[42] wl[43] wl[44] wl[45] wl[46] wl[47] wl[48] wl[49] wl[50] wl[51] wl[52] wl[53] wl[54] wl[55] wl[56] wl[57] wl[58] wl[59] wl[60] wl[61] wl[62] wl[63] bl[0] bl_n[0] bl[1] bl_n[1] bl[2] bl_n[2] bl[3] bl_n[3] bl[4] bl_n[4] bl[5] bl_n[5] bl[6] bl_n[6] bl[7] bl_n[7] bl[8] bl_n[8] bl[9] bl_n[9] bl[10] bl_n[10] bl[11] bl_n[11] bl[12] bl_n[12] bl[13] bl_n[13] bl[14] bl_n[14] bl[15] bl_n[15] bl[16] bl_n[16] bl[17] bl_n[17] bl[18] bl_n[18] bl[19] bl_n[19] bl[20] bl_n[20] bl[21] bl_n[21] bl[22] bl_n[22] bl[23] bl_n[23] bl[24] bl_n[24] bl[25] bl_n[25] bl[26] bl_n[26] bl[27] bl_n[27] bl[28] bl_n[28] bl[29] bl_n[29] bl[30] bl_n[30] bl[31] bl_n[31] SP6TArray_64X32
Xinst1x0 vss vdd wl[64] wl[65] wl[66] wl[67] wl[68] wl[69] wl[70] wl[71] wl[72] wl[73] wl[74] wl[75] wl[76] wl[77] wl[78] wl[79] wl[80] wl[81] wl[82] wl[83] wl[84] wl[85] wl[86] wl[87] wl[88] wl[89] wl[90] wl[91] wl[92] wl[93] wl[94] wl[95] wl[96] wl[97] wl[98] wl[99] wl[100] wl[101] wl[102] wl[103] wl[104] wl[105] wl[106] wl[107] wl[108] wl[109] wl[110] wl[111] wl[112] wl[113] wl[114] wl[115] wl[116] wl[117] wl[118] wl[119] wl[120] wl[121] wl[122] wl[123] wl[124] wl[125] wl[126] wl[127] bl[0] bl_n[0] bl[1] bl_n[1] bl[2] bl_n[2] bl[3] bl_n[3] bl[4] bl_n[4] bl[5] bl_n[5] bl[6] bl_n[6] bl[7] bl_n[7] bl[8] bl_n[8] bl[9] bl_n[9] bl[10] bl_n[10] bl[11] bl_n[11] bl[12] bl_n[12] bl[13] bl_n[13] bl[14] bl_n[14] bl[15] bl_n[15] bl[16] bl_n[16] bl[17] bl_n[17] bl[18] bl_n[18] bl[19] bl_n[19] bl[20] bl_n[20] bl[21] bl_n[21] bl[22] bl_n[22] bl[23] bl_n[23] bl[24] bl_n[24] bl[25] bl_n[25] bl[26] bl_n[26] bl[27] bl_n[27] bl[28] bl_n[28] bl[29] bl_n[29] bl[30] bl_n[30] bl[31] bl_n[31] SP6TArray_64X32
Xbcrow vss vdd bl[0] bl_n[0] bl[1] bl_n[1] bl[2] bl_n[2] bl[3] bl_n[3] bl[4] bl_n[4] bl[5] bl_n[5] bl[6] bl_n[6] bl[7] bl_n[7] bl[8] bl_n[8] bl[9] bl_n[9] bl[10] bl_n[10] bl[11] bl_n[11] bl[12] bl_n[12] bl[13] bl_n[13] bl[14] bl_n[14] bl[15] bl_n[15] bl[16] bl_n[16] bl[17] bl_n[17] bl[18] bl_n[18] bl[19] bl_n[19] bl[20] bl_n[20] bl[21] bl_n[21] bl[22] bl_n[22] bl[23] bl_n[23] bl[24] bl_n[24] bl[25] bl_n[25] bl[26] bl_n[26] bl[27] bl_n[27] bl[28] bl_n[28] bl[29] bl_n[29] bl[30] bl_n[30] bl[31] bl_n[31] SP6TBulkConnRow_32
Xbottombcrow vss vdd bl[0] bl_n[0] bl[1] bl_n[1] bl[2] bl_n[2] bl[3] bl_n[3] bl[4] bl_n[4] bl[5] bl_n[5] bl[6] bl_n[6] bl[7] bl_n[7] bl[8] bl_n[8] bl[9] bl_n[9] bl[10] bl_n[10] bl[11] bl_n[11] bl[12] bl_n[12] bl[13] bl_n[13] bl[14] bl_n[14] bl[15] bl_n[15] bl[16] bl_n[16] bl[17] bl_n[17] bl[18] bl_n[18] bl[19] bl_n[19] bl[20] bl_n[20] bl[21] bl_n[21] bl[22] bl_n[22] bl[23] bl_n[23] bl[24] bl_n[24] bl[25] bl_n[25] bl[26] bl_n[26] bl[27] bl_n[27] bl[28] bl_n[28] bl[29] bl_n[29] bl[30] bl_n[30] bl[31] bl_n[31] SP6TBulkConnRow_32
Xtopbcrow vss vdd bl[0] bl_n[0] bl[1] bl_n[1] bl[2] bl_n[2] bl[3] bl_n[3] bl[4] bl_n[4] bl[5] bl_n[5] bl[6] bl_n[6] bl[7] bl_n[7] bl[8] bl_n[8] bl[9] bl_n[9] bl[10] bl_n[10] bl[11] bl_n[11] bl[12] bl_n[12] bl[13] bl_n[13] bl[14] bl_n[14] bl[15] bl_n[15] bl[16] bl_n[16] bl[17] bl_n[17] bl[18] bl_n[18] bl[19] bl_n[19] bl[20] bl_n[20] bl[21] bl_n[21] bl[22] bl_n[22] bl[23] bl_n[23] bl[24] bl_n[24] bl[25] bl_n[25] bl[26] bl_n[26] bl[27] bl_n[27] bl[28] bl_n[28] bl[29] bl_n[29] bl[30] bl_n[30] bl[31] bl_n[31] SP6TBulkConnRow_32
.ends SP6TArray_128X32BC

.subckt SP6TColumn_128R8B4M vss vdd wl[0] wl[1] wl[2] wl[3] wl[4] wl[5] wl[6] wl[7] wl[8] wl[9] wl[10] wl[11] wl[12] wl[13] wl[14] wl[15] wl[16] wl[17] wl[18] wl[19] wl[20] wl[21] wl[22] wl[23] wl[24] wl[25] wl[26] wl[27] wl[28] wl[29] wl[30] wl[31] wl[32] wl[33] wl[34] wl[35] wl[36] wl[37] wl[38] wl[39] wl[40] wl[41] wl[42] wl[43] wl[44] wl[45] wl[46] wl[47] wl[48] wl[49] wl[50] wl[51] wl[52] wl[53] wl[54] wl[55] wl[56] wl[57] wl[58] wl[59] wl[60] wl[61] wl[62] wl[63] wl[64] wl[65] wl[66] wl[67] wl[68] wl[69] wl[70] wl[71] wl[72] wl[73] wl[74] wl[75] wl[76] wl[77] wl[78] wl[79] wl[80] wl[81] wl[82] wl[83] wl[84] wl[85] wl[86] wl[87] wl[88] wl[89] wl[90] wl[91] wl[92] wl[93] wl[94] wl[95] wl[96] wl[97] wl[98] wl[99] wl[100] wl[101] wl[102] wl[103] wl[104] wl[105] wl[106] wl[107] wl[108] wl[109] wl[110] wl[111] wl[112] wl[113] wl[114] wl[115] wl[116] wl[117] wl[118] wl[119] wl[120] wl[121] wl[122] wl[123] wl[124] wl[125] wl[126] wl[127] q[0] d[0] q[1] d[1] q[2] d[2] q[3] d[3] q[4] d[4] q[5] d[5] q[6] d[6] q[7] d[7] we clk we_en precharge_n mux[0] mux[1] mux[2] mux[3]
Xarray vss vdd wl[0] wl[1] wl[2] wl[3] wl[4] wl[5] wl[6] wl[7] wl[8] wl[9] wl[10] wl[11] wl[12] wl[13] wl[14] wl[15] wl[16] wl[17] wl[18] wl[19] wl[20] wl[21] wl[22] wl[23] wl[24] wl[25] wl[26] wl[27] wl[28] wl[29] wl[30] wl[31] wl[32] wl[33] wl[34] wl[35] wl[36] wl[37] wl[38] wl[39] wl[40] wl[41] wl[42] wl[43] wl[44] wl[45] wl[46] wl[47] wl[48] wl[49] wl[50] wl[51] wl[52] wl[53] wl[54] wl[55] wl[56] wl[57] wl[58] wl[59] wl[60] wl[61] wl[62] wl[63] wl[64] wl[65] wl[66] wl[67] wl[68] wl[69] wl[70] wl[71] wl[72] wl[73] wl[74] wl[75] wl[76] wl[77] wl[78] wl[79] wl[80] wl[81] wl[82] wl[83] wl[84] wl[85] wl[86] wl[87] wl[88] wl[89] wl[90] wl[91] wl[92] wl[93] wl[94] wl[95] wl[96] wl[97] wl[98] wl[99] wl[100] wl[101] wl[102] wl[103] wl[104] wl[105] wl[106] wl[107] wl[108] wl[109] wl[110] wl[111] wl[112] wl[113] wl[114] wl[115] wl[116] wl[117] wl[118] wl[119] wl[120] wl[121] wl[122] wl[123] wl[124] wl[125] wl[126] wl[127] bl[0] bl_n[0] bl[1] bl_n[1] bl[2] bl_n[2] bl[3] bl_n[3] bl[4] bl_n[4] bl[5] bl_n[5] bl[6] bl_n[6] bl[7] bl_n[7] bl[8] bl_n[8] bl[9] bl_n[9] bl[10] bl_n[10] bl[11] bl_n[11] bl[12] bl_n[12] bl[13] bl_n[13] bl[14] bl_n[14] bl[15] bl_n[15] bl[16] bl_n[16] bl[17] bl_n[17] bl[18] bl_n[18] bl[19] bl_n[19] bl[20] bl_n[20] bl[21] bl_n[21] bl[22] bl_n[22] bl[23] bl_n[23] bl[24] bl_n[24] bl[25] bl_n[25] bl[26] bl_n[26] bl[27] bl_n[27] bl[28] bl_n[28] bl[29] bl_n[29] bl[30] bl_n[30] bl[31] bl_n[31] SP6TArray_128X32BC
Xperiph vss vdd clk precharge_n we we_en q[0] d[0] bl[0] bl_n[0] bl[1] bl_n[1] bl[2] bl_n[2] bl[3] bl_n[3] q[1] d[1] bl[4] bl_n[4] bl[5] bl_n[5] bl[6] bl_n[6] bl[7] bl_n[7] q[2] d[2] bl[8] bl_n[8] bl[9] bl_n[9] bl[10] bl_n[10] bl[11] bl_n[11] q[3] d[3] bl[12] bl_n[12] bl[13] bl_n[13] bl[14] bl_n[14] bl[15] bl_n[15] q[4] d[4] bl[16] bl_n[16] bl[17] bl_n[17] bl[18] bl_n[18] bl[19] bl_n[19] q[5] d[5] bl[20] bl_n[20] bl[21] bl_n[21] bl[22] bl_n[22] bl[23] bl_n[23] q[6] d[6] bl[24] bl_n[24] bl[25] bl_n[25] bl[26] bl_n[26] bl[27] bl_n[27] q[7] d[7] bl[28] bl_n[28] bl[29] bl_n[29] bl[30] bl_n[30] bl[31] bl_n[31] mux[0] mux[1] mux[2] mux[3] SP6TColumnPeriphery_8B4M
.ends SP6TColumn_128R8B4M

.subckt SP6TColumnBlock_128R32B4M4W vss vdd clk precharge_n we_en wl[0] wl[1] wl[2] wl[3] wl[4] wl[5] wl[6] wl[7] wl[8] wl[9] wl[10] wl[11] wl[12] wl[13] wl[14] wl[15] wl[16] wl[17] wl[18] wl[19] wl[20] wl[21] wl[22] wl[23] wl[24] wl[25] wl[26] wl[27] wl[28] wl[29] wl[30] wl[31] wl[32] wl[33] wl[34] wl[35] wl[36] wl[37] wl[38] wl[39] wl[40] wl[41] wl[42] wl[43] wl[44] wl[45] wl[46] wl[47] wl[48] wl[49] wl[50] wl[51] wl[52] wl[53] wl[54] wl[55] wl[56] wl[57] wl[58] wl[59] wl[60] wl[61] wl[62] wl[63] wl[64] wl[65] wl[66] wl[67] wl[68] wl[69] wl[70] wl[71] wl[72] wl[73] wl[74] wl[75] wl[76] wl[77] wl[78] wl[79] wl[80] wl[81] wl[82] wl[83] wl[84] wl[85] wl[86] wl[87] wl[88] wl[89] wl[90] wl[91] wl[92] wl[93] wl[94] wl[95] wl[96] wl[97] wl[98] wl[99] wl[100] wl[101] wl[102] wl[103] wl[104] wl[105] wl[106] wl[107] wl[108] wl[109] wl[110] wl[111] wl[112] wl[113] wl[114] wl[115] wl[116] wl[117] wl[118] wl[119] wl[120] wl[121] wl[122] wl[123] wl[124] wl[125] wl[126] wl[127] mux[0] mux[1] mux[2] mux[3] we[0] q[0] d[0] q[1] d[1] q[2] d[2] q[3] d[3] q[4] d[4] q[5] d[5] q[6] d[6] q[7] d[7] we[1] q[8] d[8] q[9] d[9] q[10] d[10] q[11] d[11] q[12] d[12] q[13] d[13] q[14] d[14] q[15] d[15] we[2] q[16] d[16] q[17] d[17] q[18] d[18] q[19] d[19] q[20] d[20] q[21] d[21] q[22] d[22] q[23] d[23] we[3] q[24] d[24] q[25] d[25] q[26] d[26] q[27] d[27] q[28] d[28] q[29] d[29] q[30] d[30] q[31] d[31]
Xcolumn[0] vss vdd wl[0] wl[1] wl[2] wl[3] wl[4] wl[5] wl[6] wl[7] wl[8] wl[9] wl[10] wl[11] wl[12] wl[13] wl[14] wl[15] wl[16] wl[17] wl[18] wl[19] wl[20] wl[21] wl[22] wl[23] wl[24] wl[25] wl[26] wl[27] wl[28] wl[29] wl[30] wl[31] wl[32] wl[33] wl[34] wl[35] wl[36] wl[37] wl[38] wl[39] wl[40] wl[41] wl[42] wl[43] wl[44] wl[45] wl[46] wl[47] wl[48] wl[49] wl[50] wl[51] wl[52] wl[53] wl[54] wl[55] wl[56] wl[57] wl[58] wl[59] wl[60] wl[61] wl[62] wl[63] wl[64] wl[65] wl[66] wl[67] wl[68] wl[69] wl[70] wl[71] wl[72] wl[73] wl[74] wl[75] wl[76] wl[77] wl[78] wl[79] wl[80] wl[81] wl[82] wl[83] wl[84] wl[85] wl[86] wl[87] wl[88] wl[89] wl[90] wl[91] wl[92] wl[93] wl[94] wl[95] wl[96] wl[97] wl[98] wl[99] wl[100] wl[101] wl[102] wl[103] wl[104] wl[105] wl[106] wl[107] wl[108] wl[109] wl[110] wl[111] wl[112] wl[113] wl[114] wl[115] wl[116] wl[117] wl[118] wl[119] wl[120] wl[121] wl[122] wl[123] wl[124] wl[125] wl[126] wl[127] q[0] d[0] q[1] d[1] q[2] d[2] q[3] d[3] q[4] d[4] q[5] d[5] q[6] d[6] q[7] d[7] we[0] clk we_en precharge_n mux[0] mux[1] mux[2] mux[3] SP6TColumn_128R8B4M
Xcolumn[1] vss vdd wl[0] wl[1] wl[2] wl[3] wl[4] wl[5] wl[6] wl[7] wl[8] wl[9] wl[10] wl[11] wl[12] wl[13] wl[14] wl[15] wl[16] wl[17] wl[18] wl[19] wl[20] wl[21] wl[22] wl[23] wl[24] wl[25] wl[26] wl[27] wl[28] wl[29] wl[30] wl[31] wl[32] wl[33] wl[34] wl[35] wl[36] wl[37] wl[38] wl[39] wl[40] wl[41] wl[42] wl[43] wl[44] wl[45] wl[46] wl[47] wl[48] wl[49] wl[50] wl[51] wl[52] wl[53] wl[54] wl[55] wl[56] wl[57] wl[58] wl[59] wl[60] wl[61] wl[62] wl[63] wl[64] wl[65] wl[66] wl[67] wl[68] wl[69] wl[70] wl[71] wl[72] wl[73] wl[74] wl[75] wl[76] wl[77] wl[78] wl[79] wl[80] wl[81] wl[82] wl[83] wl[84] wl[85] wl[86] wl[87] wl[88] wl[89] wl[90] wl[91] wl[92] wl[93] wl[94] wl[95] wl[96] wl[97] wl[98] wl[99] wl[100] wl[101] wl[102] wl[103] wl[104] wl[105] wl[106] wl[107] wl[108] wl[109] wl[110] wl[111] wl[112] wl[113] wl[114] wl[115] wl[116] wl[117] wl[118] wl[119] wl[120] wl[121] wl[122] wl[123] wl[124] wl[125] wl[126] wl[127] q[8] d[8] q[9] d[9] q[10] d[10] q[11] d[11] q[12] d[12] q[13] d[13] q[14] d[14] q[15] d[15] we[1] clk we_en precharge_n mux[0] mux[1] mux[2] mux[3] SP6TColumn_128R8B4M
Xcolumn[2] vss vdd wl[0] wl[1] wl[2] wl[3] wl[4] wl[5] wl[6] wl[7] wl[8] wl[9] wl[10] wl[11] wl[12] wl[13] wl[14] wl[15] wl[16] wl[17] wl[18] wl[19] wl[20] wl[21] wl[22] wl[23] wl[24] wl[25] wl[26] wl[27] wl[28] wl[29] wl[30] wl[31] wl[32] wl[33] wl[34] wl[35] wl[36] wl[37] wl[38] wl[39] wl[40] wl[41] wl[42] wl[43] wl[44] wl[45] wl[46] wl[47] wl[48] wl[49] wl[50] wl[51] wl[52] wl[53] wl[54] wl[55] wl[56] wl[57] wl[58] wl[59] wl[60] wl[61] wl[62] wl[63] wl[64] wl[65] wl[66] wl[67] wl[68] wl[69] wl[70] wl[71] wl[72] wl[73] wl[74] wl[75] wl[76] wl[77] wl[78] wl[79] wl[80] wl[81] wl[82] wl[83] wl[84] wl[85] wl[86] wl[87] wl[88] wl[89] wl[90] wl[91] wl[92] wl[93] wl[94] wl[95] wl[96] wl[97] wl[98] wl[99] wl[100] wl[101] wl[102] wl[103] wl[104] wl[105] wl[106] wl[107] wl[108] wl[109] wl[110] wl[111] wl[112] wl[113] wl[114] wl[115] wl[116] wl[117] wl[118] wl[119] wl[120] wl[121] wl[122] wl[123] wl[124] wl[125] wl[126] wl[127] q[16] d[16] q[17] d[17] q[18] d[18] q[19] d[19] q[20] d[20] q[21] d[21] q[22] d[22] q[23] d[23] we[2] clk we_en precharge_n mux[0] mux[1] mux[2] mux[3] SP6TColumn_128R8B4M
Xcolumn[3] vss vdd wl[0] wl[1] wl[2] wl[3] wl[4] wl[5] wl[6] wl[7] wl[8] wl[9] wl[10] wl[11] wl[12] wl[13] wl[14] wl[15] wl[16] wl[17] wl[18] wl[19] wl[20] wl[21] wl[22] wl[23] wl[24] wl[25] wl[26] wl[27] wl[28] wl[29] wl[30] wl[31] wl[32] wl[33] wl[34] wl[35] wl[36] wl[37] wl[38] wl[39] wl[40] wl[41] wl[42] wl[43] wl[44] wl[45] wl[46] wl[47] wl[48] wl[49] wl[50] wl[51] wl[52] wl[53] wl[54] wl[55] wl[56] wl[57] wl[58] wl[59] wl[60] wl[61] wl[62] wl[63] wl[64] wl[65] wl[66] wl[67] wl[68] wl[69] wl[70] wl[71] wl[72] wl[73] wl[74] wl[75] wl[76] wl[77] wl[78] wl[79] wl[80] wl[81] wl[82] wl[83] wl[84] wl[85] wl[86] wl[87] wl[88] wl[89] wl[90] wl[91] wl[92] wl[93] wl[94] wl[95] wl[96] wl[97] wl[98] wl[99] wl[100] wl[101] wl[102] wl[103] wl[104] wl[105] wl[106] wl[107] wl[108] wl[109] wl[110] wl[111] wl[112] wl[113] wl[114] wl[115] wl[116] wl[117] wl[118] wl[119] wl[120] wl[121] wl[122] wl[123] wl[124] wl[125] wl[126] wl[127] q[24] d[24] q[25] d[25] q[26] d[26] q[27] d[27] q[28] d[28] q[29] d[29] q[30] d[30] q[31] d[31] we[3] clk we_en precharge_n mux[0] mux[1] mux[2] mux[3] SP6TColumn_128R8B4M
.ends SP6TColumnBlock_128R32B4M4W

.subckt SP6TBlock_512x32_342A4WE clk a[0] a[1] a[2] a[3] a[4] a[5] a[6] a[7] a[8] vss vdd q[0] q[1] q[2] q[3] q[4] q[5] q[6] q[7] q[8] q[9] q[10] q[11] q[12] q[13] q[14] q[15] q[16] q[17] q[18] q[19] q[20] q[21] q[22] q[23] q[24] q[25] q[26] q[27] q[28] q[29] q[30] q[31] d[0] d[1] d[2] d[3] d[4] d[5] d[6] d[7] d[8] d[9] d[10] d[11] d[12] d[13] d[14] d[15] d[16] d[17] d[18] d[19] d[20] d[21] d[22] d[23] d[24] d[25] d[26] d[27] d[28] d[29] d[30] d[31] we[0] we[1] we[2] we[3]
Xrowperiph vss vdd clk a[0] a[1] a[2] a[3] a[4] a[5] a[6] a[7] a[8] wl[0] wl[1] wl[2] wl[3] wl[4] wl[5] wl[6] wl[7] wl[8] wl[9] wl[10] wl[11] wl[12] wl[13] wl[14] wl[15] wl[16] wl[17] wl[18] wl[19] wl[20] wl[21] wl[22] wl[23] wl[24] wl[25] wl[26] wl[27] wl[28] wl[29] wl[30] wl[31] wl[32] wl[33] wl[34] wl[35] wl[36] wl[37] wl[38] wl[39] wl[40] wl[41] wl[42] wl[43] wl[44] wl[45] wl[46] wl[47] wl[48] wl[49] wl[50] wl[51] wl[52] wl[53] wl[54] wl[55] wl[56] wl[57] wl[58] wl[59] wl[60] wl[61] wl[62] wl[63] wl[64] wl[65] wl[66] wl[67] wl[68] wl[69] wl[70] wl[71] wl[72] wl[73] wl[74] wl[75] wl[76] wl[77] wl[78] wl[79] wl[80] wl[81] wl[82] wl[83] wl[84] wl[85] wl[86] wl[87] wl[88] wl[89] wl[90] wl[91] wl[92] wl[93] wl[94] wl[95] wl[96] wl[97] wl[98] wl[99] wl[100] wl[101] wl[102] wl[103] wl[104] wl[105] wl[106] wl[107] wl[108] wl[109] wl[110] wl[111] wl[112] wl[113] wl[114] wl[115] wl[116] wl[117] wl[118] wl[119] wl[120] wl[121] wl[122] wl[123] wl[124] wl[125] wl[126] wl[127] mux[0] mux[1] mux[2] mux[3] columnclk precharge_n we_en SP6TRowPeriphery_3_4_2
Xcolumnblock vss vdd columnclk precharge_n we_en wl[0] wl[1] wl[2] wl[3] wl[4] wl[5] wl[6] wl[7] wl[8] wl[9] wl[10] wl[11] wl[12] wl[13] wl[14] wl[15] wl[16] wl[17] wl[18] wl[19] wl[20] wl[21] wl[22] wl[23] wl[24] wl[25] wl[26] wl[27] wl[28] wl[29] wl[30] wl[31] wl[32] wl[33] wl[34] wl[35] wl[36] wl[37] wl[38] wl[39] wl[40] wl[41] wl[42] wl[43] wl[44] wl[45] wl[46] wl[47] wl[48] wl[49] wl[50] wl[51] wl[52] wl[53] wl[54] wl[55] wl[56] wl[57] wl[58] wl[59] wl[60] wl[61] wl[62] wl[63] wl[64] wl[65] wl[66] wl[67] wl[68] wl[69] wl[70] wl[71] wl[72] wl[73] wl[74] wl[75] wl[76] wl[77] wl[78] wl[79] wl[80] wl[81] wl[82] wl[83] wl[84] wl[85] wl[86] wl[87] wl[88] wl[89] wl[90] wl[91] wl[92] wl[93] wl[94] wl[95] wl[96] wl[97] wl[98] wl[99] wl[100] wl[101] wl[102] wl[103] wl[104] wl[105] wl[106] wl[107] wl[108] wl[109] wl[110] wl[111] wl[112] wl[113] wl[114] wl[115] wl[116] wl[117] wl[118] wl[119] wl[120] wl[121] wl[122] wl[123] wl[124] wl[125] wl[126] wl[127] mux[0] mux[1] mux[2] mux[3] we[0] q[0] d[0] q[1] d[1] q[2] d[2] q[3] d[3] q[4] d[4] q[5] d[5] q[6] d[6] q[7] d[7] we[1] q[8] d[8] q[9] d[9] q[10] d[10] q[11] d[11] q[12] d[12] q[13] d[13] q[14] d[14] q[15] d[15] we[2] q[16] d[16] q[17] d[17] q[18] d[18] q[19] d[19] q[20] d[20] q[21] d[21] q[22] d[22] q[23] d[23] we[3] q[24] d[24] q[25] d[25] q[26] d[26] q[27] d[27] q[28] d[28] q[29] d[29] q[30] d[30] q[31] d[31] SP6TColumnBlock_128R32B4M4W
.ends SP6TBlock_512x32_342A4WE

.subckt SP6TTimingIn_9SF vss vdd sr_in sr_out sr_shift sr_latch i[8] i[7] i[6] i[5] i[4] i[3] i[2] i[1] i[0]
Xshiftff[8] vdd vss sr_in sr_shift i_s[8] dff_x1
Xshiftff[7] vdd vss i_s[8] sr_shift i_s[7] dff_x1
Xshiftff[6] vdd vss i_s[7] sr_shift i_s[6] dff_x1
Xshiftff[5] vdd vss i_s[6] sr_shift i_s[5] dff_x1
Xshiftff[4] vdd vss i_s[5] sr_shift i_s[4] dff_x1
Xshiftff[3] vdd vss i_s[4] sr_shift i_s[3] dff_x1
Xshiftff[2] vdd vss i_s[3] sr_shift i_s[2] dff_x1
Xshiftff[1] vdd vss i_s[2] sr_shift i_s[1] dff_x1
Xshiftff[0] vdd vss i_s[1] sr_shift sr_out dff_x1
Xlatchff[8] vdd vss i_s[8] sr_latch i[8] dff_x1
Xlatchff[7] vdd vss i_s[7] sr_latch i[7] dff_x1
Xlatchff[6] vdd vss i_s[6] sr_latch i[6] dff_x1
Xlatchff[5] vdd vss i_s[5] sr_latch i[5] dff_x1
Xlatchff[4] vdd vss i_s[4] sr_latch i[4] dff_x1
Xlatchff[3] vdd vss i_s[3] sr_latch i[3] dff_x1
Xlatchff[2] vdd vss i_s[2] sr_latch i[2] dff_x1
Xlatchff[1] vdd vss i_s[1] sr_latch i[1] dff_x1
Xlatchff[0] vdd vss sr_out sr_latch i[0] dff_x1
.ends SP6TTimingIn_9SF

.subckt SP6TBlock_512x32_342A4WE_Test vss vdd_block vdd_periph clk in_shift in_latch in_srin in_srout out_shift out_latch out_l2s out_srin out_srout
Xblock clk a[0] a[1] a[2] a[3] a[4] a[5] a[6] a[7] a[8] vss vdd_block q[0] q[1] q[2] q[3] q[4] q[5] q[6] q[7] q[8] q[9] q[10] q[11] q[12] q[13] q[14] q[15] q[16] q[17] q[18] q[19] q[20] q[21] q[22] q[23] q[24] q[25] q[26] q[27] q[28] q[29] q[30] q[31] d[0] d[1] d[2] d[3] d[4] d[5] d[6] d[7] d[8] d[9] d[10] d[11] d[12] d[13] d[14] d[15] d[16] d[17] d[18] d[19] d[20] d[21] d[22] d[23] d[24] d[25] d[26] d[27] d[28] d[29] d[30] d[31] we[0] we[1] we[2] we[3] SP6TBlock_512x32_342A4WE
Xasr vss vdd_periph in_srin in_srconn[0] in_shift in_latch a[8] a[7] a[6] a[5] a[4] a[3] a[2] a[1] a[0] SP6TTimingIn_9SF
Xclksr vss vdd_periph out_srin out_srconn[0] out_shift clk out_l2s in_latch out_latch SP6TTimingOut_2SL
Xdwesr[0] vss vdd_periph in_srconn[0] in_srconn[1] in_shift in_latch d[0] d[1] d[2] d[3] d[4] d[5] d[6] d[7] we[0] SP6TTimingIn_9SL
Xdwesr[1] vss vdd_periph in_srconn[1] in_srconn[2] in_shift in_latch d[8] d[9] d[10] d[11] d[12] d[13] d[14] d[15] we[1] SP6TTimingIn_9SL
Xdwesr[2] vss vdd_periph in_srconn[2] in_srconn[3] in_shift in_latch d[16] d[17] d[18] d[19] d[20] d[21] d[22] d[23] we[2] SP6TTimingIn_9SL
Xdwesr[3] vss vdd_periph in_srconn[3] in_srout in_shift in_latch d[24] d[25] d[26] d[27] d[28] d[29] d[30] d[31] we[3] SP6TTimingIn_9SL
Xqsr[0] vss vdd_periph out_srconn[0] out_srconn[1] out_shift out_latch out_l2s q[0] q[1] q[2] q[3] q[4] q[5] q[6] q[7] SP6TTimingOut_8SL
Xqsr[1] vss vdd_periph out_srconn[1] out_srconn[2] out_shift out_latch out_l2s q[8] q[9] q[10] q[11] q[12] q[13] q[14] q[15] SP6TTimingOut_8SL
Xqsr[2] vss vdd_periph out_srconn[2] out_srconn[3] out_shift out_latch out_l2s q[16] q[17] q[18] q[19] q[20] q[21] q[22] q[23] SP6TTimingOut_8SL
Xqsr[3] vss vdd_periph out_srconn[3] out_srout out_shift out_latch out_l2s q[24] q[25] q[26] q[27] q[28] q[29] q[30] q[31] SP6TTimingOut_8SL
Xfill[0] vdd_periph vss fill_w2
Xfill[1] vdd_periph vss fill_w2
Xfill[2] vdd_periph vss fill_w2
Xfill[3] vdd_periph vss fill_w2
.ends SP6TBlock_512x32_342A4WE_Test

.subckt PadFrame_SP03 PAD0x0 PAD0x1 PAD0x2 PAD0x3 PAD0x4 PAD0x5 PAD0x6 PAD0x7 PAD0x8 PAD0x9 PAD1x0 PAD1x1 PAD1x2 PAD1x3 PAD1x4 PAD1x5 PAD1x6 PAD1x7 PAD1x8 PAD1x9
XPAD0x0 PAD0x0 BondPad
XPAD0x1 PAD0x1 BondPad
XPAD0x2 PAD0x2 BondPad
XPAD0x3 PAD0x3 BondPad
XPAD0x4 PAD0x4 BondPad
XPAD0x5 PAD0x5 BondPad
XPAD0x6 PAD0x6 BondPad
XPAD0x7 PAD0x7 BondPad
XPAD0x8 PAD0x8 BondPad
XPAD0x9 PAD0x9 BondPad
XPAD1x0 PAD1x0 BondPad
XPAD1x1 PAD1x1 BondPad
XPAD1x2 PAD1x2 BondPad
XPAD1x3 PAD1x3 BondPad
XPAD1x4 PAD1x4 BondPad
XPAD1x5 PAD1x5 BondPad
XPAD1x6 PAD1x6 BondPad
XPAD1x7 PAD1x7 BondPad
XPAD1x8 PAD1x8 BondPad
XPAD1x9 PAD1x9 BondPad
.ends PadFrame_SP03

.subckt SP03 vss vdd_periph vdd_block in_srout out_srout clk out_latch out_shift out_l2s out_srin in_shift in_srin in_latch
Xtestblock vss vdd_block vdd_periph clk in_shift in_latch in_srin in_srout out_shift out_latch out_l2s out_srin out_srout SP6TBlock_512x32_342A4WE_Test
Xpadframe vdd_block vss clk out_shift out_srin in_srin in_latch noconn noconn noconn vdd_periph in_srout out_srout out_latch out_l2s in_shift noconn noconn noconn noconn PadFrame_SP03
.ends SP03

.subckt DP8TNonOverlapClock_8S1R vss vdd clk firststage[0] firststage[1] firststage[2] firststage[3] firststage[4] firststage[5] firststage[6] firststage[7] firststage[8] secondstage[0] secondstage[1] secondstage[2] secondstage[3] secondstage[4] secondstage[5] secondstage[6] secondstage[7] secondstage[8]
Xclkinv vdd vss clk clk_n inv_x0
Xfirstnand2 vdd vss firststage[0] clk secondstage[8] nand2_x0
Xfirststage[0] vdd vss firststage[0] firststage[1] inv_x0
Xfirststage[1] vdd vss firststage[1] firststage[2] inv_x0
Xfirststage[2] vdd vss firststage[2] firststage[3] inv_x0
Xfirststage[3] vdd vss firststage[3] firststage[4] inv_x0
Xfirststage[4] vdd vss firststage[4] firststage[5] inv_x0
Xfirststage[5] vdd vss firststage[5] firststage[6] inv_x0
Xfirststage[6] vdd vss firststage[6] firststage[7] inv_x0
Xfirststage[7] vdd vss firststage[7] firststage[8] inv_x0
Xsecondnand2 vdd vss secondstage[0] clk_n firststage[8] nand2_x0
Xsecondstage[0] vdd vss secondstage[0] secondstage[1] inv_x0
Xsecondstage[1] vdd vss secondstage[1] secondstage[2] inv_x0
Xsecondstage[2] vdd vss secondstage[2] secondstage[3] inv_x0
Xsecondstage[3] vdd vss secondstage[3] secondstage[4] inv_x0
Xsecondstage[4] vdd vss secondstage[4] secondstage[5] inv_x0
Xsecondstage[5] vdd vss secondstage[5] secondstage[6] inv_x0
Xsecondstage[6] vdd vss secondstage[6] secondstage[7] inv_x0
Xsecondstage[7] vdd vss secondstage[7] secondstage[8] inv_x0
.ends DP8TNonOverlapClock_8S1R

.subckt DP8TClockGenerator_8S1R vss vdd clk decodeclk columnclk precharge_n wl_en we_en
Xnonovl vss vdd clk firststage[0] firststage[1] firststage[2] firststage[3] firststage[4] firststage[5] firststage[6] firstpulse firststage[8] secondstage[0] secondstage[1] secondstage[2] secondstage[3] secondstage[4] secondstage[5] secondstage[6] secondpulse secondstage[8] DP8TNonOverlapClock_8S1R
Xdecodeclkbuf vdd vss clk decodeclk buf_x1
Xprechargeinv vdd vss secondpulse precharge_n inv_x1
Xwlenbuf vdd vss firstpulse wl_en buf_x1
Xcolumnclkbuf vdd vss clk columnclk buf_x1
Xweenbuf vdd vss firstpulse we_en buf_x1
.ends DP8TClockGenerator_8S1R

.subckt DP8TDec_dff_x1 vdd vss i clk q
Xclk_nmos _clk_n clk vss vss sg13_lv_nmos l=1.3e-07 w=7.8e-07
Xclk_pmos _clk_n clk vdd vdd sg13_lv_pmos l=1.3e-07 w=1.2e-06
Xclk_n_nmos0 vss _clk_n _clk_buf vss sg13_lv_nmos l=1.3e-07 w=7.8e-07
Xclk_n_pmos0 vdd _clk_n _clk_buf vdd sg13_lv_pmos l=1.3e-07 w=1.2e-06
Xi_nmos _u i vss vss sg13_lv_nmos l=1.3e-07 w=7.8e-07
Xi_pmos _u i vdd vdd sg13_lv_pmos l=1.3e-07 w=1.2e-06
Xu_nmos vss _u _net0 vss sg13_lv_nmos l=1.3e-07 w=7.8e-07
Xu_pmos vdd _u _net1 vdd sg13_lv_pmos l=1.3e-07 w=1.2e-06
Xclk_n_nmos1 _net0 _clk_n _dff_m vss sg13_lv_nmos l=1.3e-07 w=7.8e-07
Xclk_buf_pmos0 _net1 _clk_buf _dff_m vdd sg13_lv_pmos l=1.3e-07 w=1.2e-06
Xclk_buf_nmos0 _dff_m _clk_buf _net2 vss sg13_lv_nmos l=1.3e-07 w=7.8e-07
Xclk_n_pmos1 _dff_m _clk_n _net3 vdd sg13_lv_pmos l=1.3e-07 w=1.2e-06
Xy_nmos _net2 _y vss vss sg13_lv_nmos l=1.3e-07 w=7.8e-07
Xy_pmos _net3 _y vdd vdd sg13_lv_pmos l=1.3e-07 w=1.2e-06
Xdff_m_nmos vss _dff_m _y vss sg13_lv_nmos l=1.3e-07 w=7.8e-07
Xdff_m_pmos vdd _dff_m _y vdd sg13_lv_pmos l=1.3e-07 w=1.2e-06
Xclk_buf_nmos1 _y _clk_buf _dff_s vss sg13_lv_nmos l=1.3e-07 w=7.8e-07
Xclk_n_pmos2 _y _clk_n _dff_s vdd sg13_lv_pmos l=1.3e-07 w=1.2e-06
Xclk_n_nmos2 _dff_s _clk_n _net4 vss sg13_lv_nmos l=1.3e-07 w=7.8e-07
Xclk_buf_pmos1 _dff_s _clk_buf _net5 vdd sg13_lv_pmos l=1.3e-07 w=1.2e-06
Xq_nmos _net4 q vss vss sg13_lv_nmos l=1.3e-07 w=7.8e-07
Xq_pmos _net5 q vdd vdd sg13_lv_pmos l=1.3e-07 w=1.2e-06
Xdff_s_nmos vss _dff_s q vss sg13_lv_nmos l=1.3e-07 w=2.17e-06
Xdff_s_pmos vdd _dff_s q vdd sg13_lv_pmos l=1.3e-07 w=3.77e-06
.ends DP8TDec_dff_x1

.subckt DP8TDec_inv_x1 vdd vss i nq
Xnmos vss i nq vss sg13_lv_nmos l=1.3e-07 w=2.8e-06
Xpmos vdd i nq vdd sg13_lv_pmos l=1.3e-07 w=4.4e-06
.ends DP8TDec_inv_x1

.subckt DP8TDec_nand2_x0 vdd vss nq i0 i1
Xi0_nmos vss i0 _net0 vss sg13_lv_nmos l=1.3e-07 w=7.8e-07
Xi0_pmos vdd i0 nq vdd sg13_lv_pmos l=1.3e-07 w=1.2e-06
Xi1_nmos _net0 i1 nq vss sg13_lv_nmos l=1.3e-07 w=7.8e-07
Xi1_pmos nq i1 vdd vdd sg13_lv_pmos l=1.3e-07 w=1.2e-06
.ends DP8TDec_nand2_x0

.subckt DP8TDec_inv_x2 vdd vss i nq
Xnmos[0] vss i nq vss sg13_lv_nmos l=1.3e-07 w=2.8e-06
Xpmos[0] vdd i nq vdd sg13_lv_pmos l=1.3e-07 w=4.4e-06
Xnmos[1] nq i vss vss sg13_lv_nmos l=1.3e-07 w=2.8e-06
Xpmos[1] nq i vdd vdd sg13_lv_pmos l=1.3e-07 w=4.4e-06
.ends DP8TDec_inv_x2

.subckt DP8TLatchedDecoder_2A2R vss vdd clk a[0] a[1] line[0] line[1] line[2] line[3]
Xaff[0] vdd vss a[0] clk aint[0] DP8TDec_dff_x1
Xaff[1] vdd vss a[1] clk aint[1] DP8TDec_dff_x1
Xainv[0] vdd vss aint[0] aint_n[0] DP8TDec_inv_x1
Xainv[1] vdd vss aint[1] aint_n[1] DP8TDec_inv_x1
Xlinenand[0] vdd vss line_n[0] aint_n[0] aint_n[1] DP8TDec_nand2_x0
Xlinenand[1] vdd vss line_n[1] aint[0] aint_n[1] DP8TDec_nand2_x0
Xlinenand[2] vdd vss line_n[2] aint_n[0] aint[1] DP8TDec_nand2_x0
Xlinenand[3] vdd vss line_n[3] aint[0] aint[1] DP8TDec_nand2_x0
Xlineinv[0] vdd vss line_n[0] line[0] DP8TDec_inv_x2
Xlineinv[1] vdd vss line_n[1] line[1] DP8TDec_inv_x2
Xlineinv[2] vdd vss line_n[2] line[2] DP8TDec_inv_x2
Xlineinv[3] vdd vss line_n[3] line[3] DP8TDec_inv_x2
.ends DP8TLatchedDecoder_2A2R

.subckt DP8TDec_and3_x1 vdd vss q i0 i1 i2
Xi0_nmos nq i0 _net0 vss sg13_lv_nmos l=1.3e-07 w=7.8e-07
Xi0_pmos nq i0 vdd vdd sg13_lv_pmos l=1.3e-07 w=1.2e-06
Xi1_nmos _net0 i1 _net1 vss sg13_lv_nmos l=1.3e-07 w=7.8e-07
Xi1_pmos vdd i1 nq vdd sg13_lv_pmos l=1.3e-07 w=1.2e-06
Xi2_nmos _net1 i2 vss vss sg13_lv_nmos l=1.3e-07 w=7.8e-07
Xi2_pmos nq i2 vdd vdd sg13_lv_pmos l=1.3e-07 w=1.2e-06
Xn_pd vss nq q vss sg13_lv_nmos l=1.3e-07 w=2.8e-06
Xq_pu vdd nq q vdd sg13_lv_pmos l=1.3e-07 w=4.4e-06
.ends DP8TDec_and3_x1

.subckt DP8TDec_and4_x1 vdd vss q i0 i1 i2 i3
Xi0_nmos nq i0 _net0 vss sg13_lv_nmos l=1.3e-07 w=7.8e-07
Xi0_pmos vdd i0 nq vdd sg13_lv_pmos l=1.3e-07 w=1.2e-06
Xi1_nmos _net0 i1 _net1 vss sg13_lv_nmos l=1.3e-07 w=7.8e-07
Xi1_pmos nq i1 vdd vdd sg13_lv_pmos l=1.3e-07 w=1.2e-06
Xi2_nmos _net1 i2 _net2 vss sg13_lv_nmos l=1.3e-07 w=7.8e-07
Xi2_pmos vdd i2 nq vdd sg13_lv_pmos l=1.3e-07 w=1.2e-06
Xi3_nmos _net2 i3 vss vss sg13_lv_nmos l=1.3e-07 w=7.8e-07
Xi3_pmos nq i3 vdd vdd sg13_lv_pmos l=1.3e-07 w=1.2e-06
Xn_pd vss nq q vss sg13_lv_nmos l=1.3e-07 w=2.8e-06
Xq_pu vdd nq q vdd sg13_lv_pmos l=1.3e-07 w=4.4e-06
.ends DP8TDec_and4_x1

.subckt DP8TDec_tie_diff_w4 vdd vss
.ends DP8TDec_tie_diff_w4

.subckt DP8TRowPredecoders_3_4B_wl1 vss vdd clk a[0] a[1] a[2] a[3] a[4] a[5] a[6] pd[0][0] pd[0][1] pd[0][2] pd[0][3] pd[0][4] pd[0][5] pd[0][6] pd[0][7] page[0] page[1] page[2] page[3] page[4] page[5] page[6] page[7] page[8] page[9] page[10] page[11] page[12] page[13] page[14] page[15]
Xaff[0] vdd vss a[0] clk aint[0] DP8TDec_dff_x1
Xaff[1] vdd vss a[1] clk aint[1] DP8TDec_dff_x1
Xaff[2] vdd vss a[2] clk aint[2] DP8TDec_dff_x1
Xaff[3] vdd vss a[3] clk aint[3] DP8TDec_dff_x1
Xaff[4] vdd vss a[4] clk aint[4] DP8TDec_dff_x1
Xaff[5] vdd vss a[5] clk aint[5] DP8TDec_dff_x1
Xaff[6] vdd vss a[6] clk aint[6] DP8TDec_dff_x1
Xainv[0] vdd vss aint[0] aint_n[0] DP8TDec_inv_x1
Xainv[1] vdd vss aint[1] aint_n[1] DP8TDec_inv_x1
Xainv[2] vdd vss aint[2] aint_n[2] DP8TDec_inv_x1
Xainv[3] vdd vss aint[3] aint_n[3] DP8TDec_inv_x1
Xainv[4] vdd vss aint[4] aint_n[4] DP8TDec_inv_x1
Xainv[5] vdd vss aint[5] aint_n[5] DP8TDec_inv_x1
Xainv[6] vdd vss aint[6] aint_n[6] DP8TDec_inv_x1
Xpd[0]and[0] vdd vss pd[0][0] aint_n[0] aint_n[1] aint_n[2] DP8TDec_and3_x1
Xpd[0]and[1] vdd vss pd[0][1] aint[0] aint_n[1] aint_n[2] DP8TDec_and3_x1
Xpd[0]and[2] vdd vss pd[0][2] aint_n[0] aint[1] aint_n[2] DP8TDec_and3_x1
Xpd[0]and[3] vdd vss pd[0][3] aint[0] aint[1] aint_n[2] DP8TDec_and3_x1
Xpd[0]and[4] vdd vss pd[0][4] aint_n[0] aint_n[1] aint[2] DP8TDec_and3_x1
Xpd[0]and[5] vdd vss pd[0][5] aint[0] aint_n[1] aint[2] DP8TDec_and3_x1
Xpd[0]and[6] vdd vss pd[0][6] aint_n[0] aint[1] aint[2] DP8TDec_and3_x1
Xpd[0]and[7] vdd vss pd[0][7] aint[0] aint[1] aint[2] DP8TDec_and3_x1
Xpage_and[0] vdd vss page[0] aint_n[3] aint_n[4] aint_n[5] aint_n[6] DP8TDec_and4_x1
Xpage_and[1] vdd vss page[1] aint[3] aint_n[4] aint_n[5] aint_n[6] DP8TDec_and4_x1
Xpage_and[2] vdd vss page[2] aint_n[3] aint[4] aint_n[5] aint_n[6] DP8TDec_and4_x1
Xpage_and[3] vdd vss page[3] aint[3] aint[4] aint_n[5] aint_n[6] DP8TDec_and4_x1
Xpage_and[4] vdd vss page[4] aint_n[3] aint_n[4] aint[5] aint_n[6] DP8TDec_and4_x1
Xpage_and[5] vdd vss page[5] aint[3] aint_n[4] aint[5] aint_n[6] DP8TDec_and4_x1
Xpage_and[6] vdd vss page[6] aint_n[3] aint[4] aint[5] aint_n[6] DP8TDec_and4_x1
Xpage_and[7] vdd vss page[7] aint[3] aint[4] aint[5] aint_n[6] DP8TDec_and4_x1
Xpage_and[8] vdd vss page[8] aint_n[3] aint_n[4] aint_n[5] aint[6] DP8TDec_and4_x1
Xpage_and[9] vdd vss page[9] aint[3] aint_n[4] aint_n[5] aint[6] DP8TDec_and4_x1
Xpage_and[10] vdd vss page[10] aint_n[3] aint[4] aint_n[5] aint[6] DP8TDec_and4_x1
Xpage_and[11] vdd vss page[11] aint[3] aint[4] aint_n[5] aint[6] DP8TDec_and4_x1
Xpage_and[12] vdd vss page[12] aint_n[3] aint_n[4] aint[5] aint[6] DP8TDec_and4_x1
Xpage_and[13] vdd vss page[13] aint[3] aint_n[4] aint[5] aint[6] DP8TDec_and4_x1
Xpage_and[14] vdd vss page[14] aint_n[3] aint[4] aint[5] aint[6] DP8TDec_and4_x1
Xpage_and[15] vdd vss page[15] aint[3] aint[4] aint[5] aint[6] DP8TDec_and4_x1
Xtie[0] vdd vss DP8TDec_tie_diff_w4
Xtie[1] vdd vss DP8TDec_tie_diff_w4
Xtie[2] vdd vss DP8TDec_tie_diff_w4
Xtie[3] vdd vss DP8TDec_tie_diff_w4
Xtie[4] vdd vss DP8TDec_tie_diff_w4
Xtie[5] vdd vss DP8TDec_tie_diff_w4
Xtie[6] vdd vss DP8TDec_tie_diff_w4
Xtie[7] vdd vss DP8TDec_tie_diff_w4
Xtie[8] vdd vss DP8TDec_tie_diff_w4
Xtie[9] vdd vss DP8TDec_tie_diff_w4
Xtie[10] vdd vss DP8TDec_tie_diff_w4
Xtie[11] vdd vss DP8TDec_tie_diff_w4
Xtie[12] vdd vss DP8TDec_tie_diff_w4
Xtie[13] vdd vss DP8TDec_tie_diff_w4
Xtie[14] vdd vss DP8TDec_tie_diff_w4
Xtie[15] vdd vss DP8TDec_tie_diff_w4
Xtie[16] vdd vss DP8TDec_tie_diff_w4
Xtie[17] vdd vss DP8TDec_tie_diff_w4
Xtie[18] vdd vss DP8TDec_tie_diff_w4
Xtie[19] vdd vss DP8TDec_tie_diff_w4
Xtie[20] vdd vss DP8TDec_tie_diff_w4
Xtie[21] vdd vss DP8TDec_tie_diff_w4
Xtie[22] vdd vss DP8TDec_tie_diff_w4
Xtie[23] vdd vss DP8TDec_tie_diff_w4
Xtie[24] vdd vss DP8TDec_tie_diff_w4
Xtie[25] vdd vss DP8TDec_tie_diff_w4
Xtie[25] vdd vss DP8TDec_tie_diff_w4
Xtie[25] vdd vss DP8TDec_tie_diff_w4
Xtie[25] vdd vss DP8TDec_tie_diff_w4
Xtie[25] vdd vss DP8TDec_tie_diff_w4
Xtie[25] vdd vss DP8TDec_tie_diff_w4
Xtie[25] vdd vss DP8TDec_tie_diff_w4
Xtie[25] vdd vss DP8TDec_tie_diff_w4
Xtie[25] vdd vss DP8TDec_tie_diff_w4
Xtie[25] vdd vss DP8TDec_tie_diff_w4
Xtie[25] vdd vss DP8TDec_tie_diff_w4
Xtie[25] vdd vss DP8TDec_tie_diff_w4
Xtie[25] vdd vss DP8TDec_tie_diff_w4
Xtie[25] vdd vss DP8TDec_tie_diff_w4
Xtie[25] vdd vss DP8TDec_tie_diff_w4
Xtie[25] vdd vss DP8TDec_tie_diff_w4
Xtie[25] vdd vss DP8TDec_tie_diff_w4
Xtie[25] vdd vss DP8TDec_tie_diff_w4
Xtie[25] vdd vss DP8TDec_tie_diff_w4
Xtie[25] vdd vss DP8TDec_tie_diff_w4
Xtie[25] vdd vss DP8TDec_tie_diff_w4
Xtie[25] vdd vss DP8TDec_tie_diff_w4
.ends DP8TRowPredecoders_3_4B_wl1

.subckt DP8TRowDecoderNand3X2 vss vdd pd[0][0] pd[0][1] page wl_en wl_n[0] wl_n[1]
Xnmos[0] wl_n[0] wl_en int[0] vss sg13_lv_nmos l=1.3e-07 w=5e-07
Xnmos[1] int[0] pd[0][0] int[1] vss sg13_lv_nmos l=1.3e-07 w=5e-07
Xnmos[2] int[1] page vss vss sg13_lv_nmos l=1.3e-07 w=5e-07
Xnmos[3] vss page int[2] vss sg13_lv_nmos l=1.3e-07 w=5e-07
Xnmos[4] int[2] pd[0][1] int[3] vss sg13_lv_nmos l=1.3e-07 w=5e-07
Xnmos[5] int[3] wl_en wl_n[1] vss sg13_lv_nmos l=1.3e-07 w=5e-07
Xpmos[0] wl_n[0] wl_en vdd vdd sg13_lv_pmos l=1.3e-07 w=5e-07
Xpmos[1] vdd pd[0][0] wl_n[0] vdd sg13_lv_pmos l=1.3e-07 w=5e-07
Xpmos[2] wl_n[0] page vdd vdd sg13_lv_pmos l=1.3e-07 w=5e-07
Xpmos[3] vdd page wl_n[1] vdd sg13_lv_pmos l=1.3e-07 w=5e-07
Xpmos[4] wl_n[1] pd[0][1] vdd vdd sg13_lv_pmos l=1.3e-07 w=5e-07
Xpmos[5] vdd wl_en wl_n[1] vdd sg13_lv_pmos l=1.3e-07 w=5e-07
.ends DP8TRowDecoderNand3X2

.subckt DP8TWLDrive_26LN100WN26LP200WP_wl1 vss vdd wl_n wl_drive
Xnmos1 vss wl_n wl_drive vss sg13_lv_nmos l=1.3e-07 w=5e-07
Xnmos2 wl_drive wl_n vss vss sg13_lv_nmos l=1.3e-07 w=5e-07
Xpmos1 vdd wl_n wl_drive vdd sg13_lv_pmos l=1.3e-07 w=1e-06
Xpmos2 wl_drive wl_n vdd vdd sg13_lv_pmos l=1.3e-07 w=1e-06
.ends DP8TWLDrive_26LN100WN26LP200WP_wl1

.subckt DP8TRowDecoderDriverPage_2PD8R_wl1 vss vdd wl[0] wl[1] wl[2] wl[3] wl[4] wl[5] wl[6] wl[7] pd[0][0] pd[0][1] pd[0][2] pd[0][3] pd[0][4] pd[0][5] pd[0][6] pd[0][7] page wl_en
Xnand3[0] vss vdd pd[0][0] pd[0][1] page wl_en wl_n[0] wl_n[1] DP8TRowDecoderNand3X2
Xnand3[1] vss vdd pd[0][2] pd[0][3] page wl_en wl_n[2] wl_n[3] DP8TRowDecoderNand3X2
Xnand3[2] vss vdd pd[0][4] pd[0][5] page wl_en wl_n[4] wl_n[5] DP8TRowDecoderNand3X2
Xnand3[3] vss vdd pd[0][6] pd[0][7] page wl_en wl_n[6] wl_n[7] DP8TRowDecoderNand3X2
Xdrive[0] vss vdd wl_n[0] wl[0] DP8TWLDrive_26LN100WN26LP200WP_wl1
Xdrive[1] vss vdd wl_n[1] wl[1] DP8TWLDrive_26LN100WN26LP200WP_wl1
Xdrive[2] vss vdd wl_n[2] wl[2] DP8TWLDrive_26LN100WN26LP200WP_wl1
Xdrive[3] vss vdd wl_n[3] wl[3] DP8TWLDrive_26LN100WN26LP200WP_wl1
Xdrive[4] vss vdd wl_n[4] wl[4] DP8TWLDrive_26LN100WN26LP200WP_wl1
Xdrive[5] vss vdd wl_n[5] wl[5] DP8TWLDrive_26LN100WN26LP200WP_wl1
Xdrive[6] vss vdd wl_n[6] wl[6] DP8TWLDrive_26LN100WN26LP200WP_wl1
Xdrive[7] vss vdd wl_n[7] wl[7] DP8TWLDrive_26LN100WN26LP200WP_wl1
.ends DP8TRowDecoderDriverPage_2PD8R_wl1

.subckt DP8TRowDecoderBulkConn vdd vss
.ends DP8TRowDecoderBulkConn

.subckt DP8TRowDecoder_3_4B_wl1 vss vdd a[0] a[1] a[2] a[3] a[4] a[5] a[6] clk wl_en wl[0] wl[1] wl[2] wl[3] wl[4] wl[5] wl[6] wl[7] wl[8] wl[9] wl[10] wl[11] wl[12] wl[13] wl[14] wl[15] wl[16] wl[17] wl[18] wl[19] wl[20] wl[21] wl[22] wl[23] wl[24] wl[25] wl[26] wl[27] wl[28] wl[29] wl[30] wl[31] wl[32] wl[33] wl[34] wl[35] wl[36] wl[37] wl[38] wl[39] wl[40] wl[41] wl[42] wl[43] wl[44] wl[45] wl[46] wl[47] wl[48] wl[49] wl[50] wl[51] wl[52] wl[53] wl[54] wl[55] wl[56] wl[57] wl[58] wl[59] wl[60] wl[61] wl[62] wl[63] wl[64] wl[65] wl[66] wl[67] wl[68] wl[69] wl[70] wl[71] wl[72] wl[73] wl[74] wl[75] wl[76] wl[77] wl[78] wl[79] wl[80] wl[81] wl[82] wl[83] wl[84] wl[85] wl[86] wl[87] wl[88] wl[89] wl[90] wl[91] wl[92] wl[93] wl[94] wl[95] wl[96] wl[97] wl[98] wl[99] wl[100] wl[101] wl[102] wl[103] wl[104] wl[105] wl[106] wl[107] wl[108] wl[109] wl[110] wl[111] wl[112] wl[113] wl[114] wl[115] wl[116] wl[117] wl[118] wl[119] wl[120] wl[121] wl[122] wl[123] wl[124] wl[125] wl[126] wl[127]
Xpredec vss vdd clk a[0] a[1] a[2] a[3] a[4] a[5] a[6] pd[0][0] pd[0][1] pd[0][2] pd[0][3] pd[0][4] pd[0][5] pd[0][6] pd[0][7] page[0] page[1] page[2] page[3] page[4] page[5] page[6] page[7] page[8] page[9] page[10] page[11] page[12] page[13] page[14] page[15] DP8TRowPredecoders_3_4B_wl1
Xpage[0] vss vdd wl[0] wl[1] wl[2] wl[3] wl[4] wl[5] wl[6] wl[7] pd[0][0] pd[0][1] pd[0][2] pd[0][3] pd[0][4] pd[0][5] pd[0][6] pd[0][7] page[0] wl_en DP8TRowDecoderDriverPage_2PD8R_wl1
Xpage[1] vss vdd wl[8] wl[9] wl[10] wl[11] wl[12] wl[13] wl[14] wl[15] pd[0][0] pd[0][1] pd[0][2] pd[0][3] pd[0][4] pd[0][5] pd[0][6] pd[0][7] page[1] wl_en DP8TRowDecoderDriverPage_2PD8R_wl1
Xpage[2] vss vdd wl[16] wl[17] wl[18] wl[19] wl[20] wl[21] wl[22] wl[23] pd[0][0] pd[0][1] pd[0][2] pd[0][3] pd[0][4] pd[0][5] pd[0][6] pd[0][7] page[2] wl_en DP8TRowDecoderDriverPage_2PD8R_wl1
Xpage[3] vss vdd wl[24] wl[25] wl[26] wl[27] wl[28] wl[29] wl[30] wl[31] pd[0][0] pd[0][1] pd[0][2] pd[0][3] pd[0][4] pd[0][5] pd[0][6] pd[0][7] page[3] wl_en DP8TRowDecoderDriverPage_2PD8R_wl1
Xpage[4] vss vdd wl[32] wl[33] wl[34] wl[35] wl[36] wl[37] wl[38] wl[39] pd[0][0] pd[0][1] pd[0][2] pd[0][3] pd[0][4] pd[0][5] pd[0][6] pd[0][7] page[4] wl_en DP8TRowDecoderDriverPage_2PD8R_wl1
Xpage[5] vss vdd wl[40] wl[41] wl[42] wl[43] wl[44] wl[45] wl[46] wl[47] pd[0][0] pd[0][1] pd[0][2] pd[0][3] pd[0][4] pd[0][5] pd[0][6] pd[0][7] page[5] wl_en DP8TRowDecoderDriverPage_2PD8R_wl1
Xpage[6] vss vdd wl[48] wl[49] wl[50] wl[51] wl[52] wl[53] wl[54] wl[55] pd[0][0] pd[0][1] pd[0][2] pd[0][3] pd[0][4] pd[0][5] pd[0][6] pd[0][7] page[6] wl_en DP8TRowDecoderDriverPage_2PD8R_wl1
Xpage[7] vss vdd wl[56] wl[57] wl[58] wl[59] wl[60] wl[61] wl[62] wl[63] pd[0][0] pd[0][1] pd[0][2] pd[0][3] pd[0][4] pd[0][5] pd[0][6] pd[0][7] page[7] wl_en DP8TRowDecoderDriverPage_2PD8R_wl1
Xpage[8] vss vdd wl[64] wl[65] wl[66] wl[67] wl[68] wl[69] wl[70] wl[71] pd[0][0] pd[0][1] pd[0][2] pd[0][3] pd[0][4] pd[0][5] pd[0][6] pd[0][7] page[8] wl_en DP8TRowDecoderDriverPage_2PD8R_wl1
Xpage[9] vss vdd wl[72] wl[73] wl[74] wl[75] wl[76] wl[77] wl[78] wl[79] pd[0][0] pd[0][1] pd[0][2] pd[0][3] pd[0][4] pd[0][5] pd[0][6] pd[0][7] page[9] wl_en DP8TRowDecoderDriverPage_2PD8R_wl1
Xpage[10] vss vdd wl[80] wl[81] wl[82] wl[83] wl[84] wl[85] wl[86] wl[87] pd[0][0] pd[0][1] pd[0][2] pd[0][3] pd[0][4] pd[0][5] pd[0][6] pd[0][7] page[10] wl_en DP8TRowDecoderDriverPage_2PD8R_wl1
Xpage[11] vss vdd wl[88] wl[89] wl[90] wl[91] wl[92] wl[93] wl[94] wl[95] pd[0][0] pd[0][1] pd[0][2] pd[0][3] pd[0][4] pd[0][5] pd[0][6] pd[0][7] page[11] wl_en DP8TRowDecoderDriverPage_2PD8R_wl1
Xpage[12] vss vdd wl[96] wl[97] wl[98] wl[99] wl[100] wl[101] wl[102] wl[103] pd[0][0] pd[0][1] pd[0][2] pd[0][3] pd[0][4] pd[0][5] pd[0][6] pd[0][7] page[12] wl_en DP8TRowDecoderDriverPage_2PD8R_wl1
Xpage[13] vss vdd wl[104] wl[105] wl[106] wl[107] wl[108] wl[109] wl[110] wl[111] pd[0][0] pd[0][1] pd[0][2] pd[0][3] pd[0][4] pd[0][5] pd[0][6] pd[0][7] page[13] wl_en DP8TRowDecoderDriverPage_2PD8R_wl1
Xpage[14] vss vdd wl[112] wl[113] wl[114] wl[115] wl[116] wl[117] wl[118] wl[119] pd[0][0] pd[0][1] pd[0][2] pd[0][3] pd[0][4] pd[0][5] pd[0][6] pd[0][7] page[14] wl_en DP8TRowDecoderDriverPage_2PD8R_wl1
Xpage[15] vss vdd wl[120] wl[121] wl[122] wl[123] wl[124] wl[125] wl[126] wl[127] pd[0][0] pd[0][1] pd[0][2] pd[0][3] pd[0][4] pd[0][5] pd[0][6] pd[0][7] page[15] wl_en DP8TRowDecoderDriverPage_2PD8R_wl1
Xbulkcon[0] vdd vss DP8TRowDecoderBulkConn
Xbulkcon[1] vdd vss DP8TRowDecoderBulkConn
Xbulkcon[2] vdd vss DP8TRowDecoderBulkConn
Xbulkcon[3] vdd vss DP8TRowDecoderBulkConn
Xbulkcon[4] vdd vss DP8TRowDecoderBulkConn
Xbulkcon[5] vdd vss DP8TRowDecoderBulkConn
Xbulkcon[6] vdd vss DP8TRowDecoderBulkConn
Xbulkcon[7] vdd vss DP8TRowDecoderBulkConn
Xbulkcon[8] vdd vss DP8TRowDecoderBulkConn
.ends DP8TRowDecoder_3_4B_wl1

.subckt DP8TRowPeriphery_3_4_2_wl1 vss vdd clk a[0] a[1] a[2] a[3] a[4] a[5] a[6] a[7] a[8] wl[0] wl[1] wl[2] wl[3] wl[4] wl[5] wl[6] wl[7] wl[8] wl[9] wl[10] wl[11] wl[12] wl[13] wl[14] wl[15] wl[16] wl[17] wl[18] wl[19] wl[20] wl[21] wl[22] wl[23] wl[24] wl[25] wl[26] wl[27] wl[28] wl[29] wl[30] wl[31] wl[32] wl[33] wl[34] wl[35] wl[36] wl[37] wl[38] wl[39] wl[40] wl[41] wl[42] wl[43] wl[44] wl[45] wl[46] wl[47] wl[48] wl[49] wl[50] wl[51] wl[52] wl[53] wl[54] wl[55] wl[56] wl[57] wl[58] wl[59] wl[60] wl[61] wl[62] wl[63] wl[64] wl[65] wl[66] wl[67] wl[68] wl[69] wl[70] wl[71] wl[72] wl[73] wl[74] wl[75] wl[76] wl[77] wl[78] wl[79] wl[80] wl[81] wl[82] wl[83] wl[84] wl[85] wl[86] wl[87] wl[88] wl[89] wl[90] wl[91] wl[92] wl[93] wl[94] wl[95] wl[96] wl[97] wl[98] wl[99] wl[100] wl[101] wl[102] wl[103] wl[104] wl[105] wl[106] wl[107] wl[108] wl[109] wl[110] wl[111] wl[112] wl[113] wl[114] wl[115] wl[116] wl[117] wl[118] wl[119] wl[120] wl[121] wl[122] wl[123] wl[124] wl[125] wl[126] wl[127] mux[0] mux[1] mux[2] mux[3] columnclk precharge_n we_en
Xclkgen vss vdd clk decodeclk columnclk precharge_n wl_en we_en DP8TClockGenerator_8S1R
Xcoldec vss vdd decodeclk a[0] a[1] mux[0] mux[1] mux[2] mux[3] DP8TLatchedDecoder_2A2R
Xrowdec vss vdd a[2] a[3] a[4] a[5] a[6] a[7] a[8] decodeclk wl_en wl[0] wl[1] wl[2] wl[3] wl[4] wl[5] wl[6] wl[7] wl[8] wl[9] wl[10] wl[11] wl[12] wl[13] wl[14] wl[15] wl[16] wl[17] wl[18] wl[19] wl[20] wl[21] wl[22] wl[23] wl[24] wl[25] wl[26] wl[27] wl[28] wl[29] wl[30] wl[31] wl[32] wl[33] wl[34] wl[35] wl[36] wl[37] wl[38] wl[39] wl[40] wl[41] wl[42] wl[43] wl[44] wl[45] wl[46] wl[47] wl[48] wl[49] wl[50] wl[51] wl[52] wl[53] wl[54] wl[55] wl[56] wl[57] wl[58] wl[59] wl[60] wl[61] wl[62] wl[63] wl[64] wl[65] wl[66] wl[67] wl[68] wl[69] wl[70] wl[71] wl[72] wl[73] wl[74] wl[75] wl[76] wl[77] wl[78] wl[79] wl[80] wl[81] wl[82] wl[83] wl[84] wl[85] wl[86] wl[87] wl[88] wl[89] wl[90] wl[91] wl[92] wl[93] wl[94] wl[95] wl[96] wl[97] wl[98] wl[99] wl[100] wl[101] wl[102] wl[103] wl[104] wl[105] wl[106] wl[107] wl[108] wl[109] wl[110] wl[111] wl[112] wl[113] wl[114] wl[115] wl[116] wl[117] wl[118] wl[119] wl[120] wl[121] wl[122] wl[123] wl[124] wl[125] wl[126] wl[127] DP8TRowDecoder_3_4B_wl1
.ends DP8TRowPeriphery_3_4_2_wl1

.subckt DP8TRowPredecoders_3_4B_wl2 vss vdd clk a[0] a[1] a[2] a[3] a[4] a[5] a[6] pd[0][0] pd[0][1] pd[0][2] pd[0][3] pd[0][4] pd[0][5] pd[0][6] pd[0][7] page[0] page[1] page[2] page[3] page[4] page[5] page[6] page[7] page[8] page[9] page[10] page[11] page[12] page[13] page[14] page[15]
Xaff[0] vdd vss a[0] clk aint[0] DP8TDec_dff_x1
Xaff[1] vdd vss a[1] clk aint[1] DP8TDec_dff_x1
Xaff[2] vdd vss a[2] clk aint[2] DP8TDec_dff_x1
Xaff[3] vdd vss a[3] clk aint[3] DP8TDec_dff_x1
Xaff[4] vdd vss a[4] clk aint[4] DP8TDec_dff_x1
Xaff[5] vdd vss a[5] clk aint[5] DP8TDec_dff_x1
Xaff[6] vdd vss a[6] clk aint[6] DP8TDec_dff_x1
Xainv[0] vdd vss aint[0] aint_n[0] DP8TDec_inv_x1
Xainv[1] vdd vss aint[1] aint_n[1] DP8TDec_inv_x1
Xainv[2] vdd vss aint[2] aint_n[2] DP8TDec_inv_x1
Xainv[3] vdd vss aint[3] aint_n[3] DP8TDec_inv_x1
Xainv[4] vdd vss aint[4] aint_n[4] DP8TDec_inv_x1
Xainv[5] vdd vss aint[5] aint_n[5] DP8TDec_inv_x1
Xainv[6] vdd vss aint[6] aint_n[6] DP8TDec_inv_x1
Xpd[0]and[0] vdd vss pd[0][0] aint_n[0] aint_n[1] aint_n[2] DP8TDec_and3_x1
Xpd[0]and[1] vdd vss pd[0][1] aint[0] aint_n[1] aint_n[2] DP8TDec_and3_x1
Xpd[0]and[2] vdd vss pd[0][2] aint_n[0] aint[1] aint_n[2] DP8TDec_and3_x1
Xpd[0]and[3] vdd vss pd[0][3] aint[0] aint[1] aint_n[2] DP8TDec_and3_x1
Xpd[0]and[4] vdd vss pd[0][4] aint_n[0] aint_n[1] aint[2] DP8TDec_and3_x1
Xpd[0]and[5] vdd vss pd[0][5] aint[0] aint_n[1] aint[2] DP8TDec_and3_x1
Xpd[0]and[6] vdd vss pd[0][6] aint_n[0] aint[1] aint[2] DP8TDec_and3_x1
Xpd[0]and[7] vdd vss pd[0][7] aint[0] aint[1] aint[2] DP8TDec_and3_x1
Xpage_and[0] vdd vss page[0] aint_n[3] aint_n[4] aint_n[5] aint_n[6] DP8TDec_and4_x1
Xpage_and[1] vdd vss page[1] aint[3] aint_n[4] aint_n[5] aint_n[6] DP8TDec_and4_x1
Xpage_and[2] vdd vss page[2] aint_n[3] aint[4] aint_n[5] aint_n[6] DP8TDec_and4_x1
Xpage_and[3] vdd vss page[3] aint[3] aint[4] aint_n[5] aint_n[6] DP8TDec_and4_x1
Xpage_and[4] vdd vss page[4] aint_n[3] aint_n[4] aint[5] aint_n[6] DP8TDec_and4_x1
Xpage_and[5] vdd vss page[5] aint[3] aint_n[4] aint[5] aint_n[6] DP8TDec_and4_x1
Xpage_and[6] vdd vss page[6] aint_n[3] aint[4] aint[5] aint_n[6] DP8TDec_and4_x1
Xpage_and[7] vdd vss page[7] aint[3] aint[4] aint[5] aint_n[6] DP8TDec_and4_x1
Xpage_and[8] vdd vss page[8] aint_n[3] aint_n[4] aint_n[5] aint[6] DP8TDec_and4_x1
Xpage_and[9] vdd vss page[9] aint[3] aint_n[4] aint_n[5] aint[6] DP8TDec_and4_x1
Xpage_and[10] vdd vss page[10] aint_n[3] aint[4] aint_n[5] aint[6] DP8TDec_and4_x1
Xpage_and[11] vdd vss page[11] aint[3] aint[4] aint_n[5] aint[6] DP8TDec_and4_x1
Xpage_and[12] vdd vss page[12] aint_n[3] aint_n[4] aint[5] aint[6] DP8TDec_and4_x1
Xpage_and[13] vdd vss page[13] aint[3] aint_n[4] aint[5] aint[6] DP8TDec_and4_x1
Xpage_and[14] vdd vss page[14] aint_n[3] aint[4] aint[5] aint[6] DP8TDec_and4_x1
Xpage_and[15] vdd vss page[15] aint[3] aint[4] aint[5] aint[6] DP8TDec_and4_x1
Xtie[0] vdd vss DP8TDec_tie_diff_w4
Xtie[1] vdd vss DP8TDec_tie_diff_w4
Xtie[2] vdd vss DP8TDec_tie_diff_w4
Xtie[3] vdd vss DP8TDec_tie_diff_w4
Xtie[4] vdd vss DP8TDec_tie_diff_w4
Xtie[5] vdd vss DP8TDec_tie_diff_w4
Xtie[6] vdd vss DP8TDec_tie_diff_w4
Xtie[7] vdd vss DP8TDec_tie_diff_w4
Xtie[8] vdd vss DP8TDec_tie_diff_w4
Xtie[9] vdd vss DP8TDec_tie_diff_w4
Xtie[10] vdd vss DP8TDec_tie_diff_w4
Xtie[11] vdd vss DP8TDec_tie_diff_w4
Xtie[12] vdd vss DP8TDec_tie_diff_w4
Xtie[13] vdd vss DP8TDec_tie_diff_w4
Xtie[14] vdd vss DP8TDec_tie_diff_w4
Xtie[15] vdd vss DP8TDec_tie_diff_w4
Xtie[16] vdd vss DP8TDec_tie_diff_w4
Xtie[17] vdd vss DP8TDec_tie_diff_w4
Xtie[18] vdd vss DP8TDec_tie_diff_w4
Xtie[19] vdd vss DP8TDec_tie_diff_w4
Xtie[20] vdd vss DP8TDec_tie_diff_w4
Xtie[21] vdd vss DP8TDec_tie_diff_w4
Xtie[22] vdd vss DP8TDec_tie_diff_w4
Xtie[23] vdd vss DP8TDec_tie_diff_w4
Xtie[24] vdd vss DP8TDec_tie_diff_w4
Xtie[25] vdd vss DP8TDec_tie_diff_w4
Xtie[25] vdd vss DP8TDec_tie_diff_w4
Xtie[25] vdd vss DP8TDec_tie_diff_w4
Xtie[25] vdd vss DP8TDec_tie_diff_w4
Xtie[25] vdd vss DP8TDec_tie_diff_w4
Xtie[25] vdd vss DP8TDec_tie_diff_w4
Xtie[25] vdd vss DP8TDec_tie_diff_w4
Xtie[25] vdd vss DP8TDec_tie_diff_w4
Xtie[25] vdd vss DP8TDec_tie_diff_w4
Xtie[25] vdd vss DP8TDec_tie_diff_w4
Xtie[25] vdd vss DP8TDec_tie_diff_w4
Xtie[25] vdd vss DP8TDec_tie_diff_w4
Xtie[25] vdd vss DP8TDec_tie_diff_w4
Xtie[25] vdd vss DP8TDec_tie_diff_w4
Xtie[25] vdd vss DP8TDec_tie_diff_w4
Xtie[25] vdd vss DP8TDec_tie_diff_w4
Xtie[25] vdd vss DP8TDec_tie_diff_w4
Xtie[25] vdd vss DP8TDec_tie_diff_w4
Xtie[25] vdd vss DP8TDec_tie_diff_w4
Xtie[25] vdd vss DP8TDec_tie_diff_w4
Xtie[25] vdd vss DP8TDec_tie_diff_w4
Xtie[25] vdd vss DP8TDec_tie_diff_w4
.ends DP8TRowPredecoders_3_4B_wl2

.subckt DP8TWLDrive_26LN100WN26LP200WP_wl2 vss vdd wl_n wl_drive
Xnmos1 vss wl_n wl_drive vss sg13_lv_nmos l=1.3e-07 w=5e-07
Xnmos2 wl_drive wl_n vss vss sg13_lv_nmos l=1.3e-07 w=5e-07
Xpmos1 vdd wl_n wl_drive vdd sg13_lv_pmos l=1.3e-07 w=1e-06
Xpmos2 wl_drive wl_n vdd vdd sg13_lv_pmos l=1.3e-07 w=1e-06
.ends DP8TWLDrive_26LN100WN26LP200WP_wl2

.subckt DP8TRowDecoderDriverPage_2PD8R_wl2 vss vdd wl[0] wl[1] wl[2] wl[3] wl[4] wl[5] wl[6] wl[7] pd[0][0] pd[0][1] pd[0][2] pd[0][3] pd[0][4] pd[0][5] pd[0][6] pd[0][7] page wl_en
Xnand3[0] vss vdd pd[0][0] pd[0][1] page wl_en wl_n[0] wl_n[1] DP8TRowDecoderNand3X2
Xnand3[1] vss vdd pd[0][2] pd[0][3] page wl_en wl_n[2] wl_n[3] DP8TRowDecoderNand3X2
Xnand3[2] vss vdd pd[0][4] pd[0][5] page wl_en wl_n[4] wl_n[5] DP8TRowDecoderNand3X2
Xnand3[3] vss vdd pd[0][6] pd[0][7] page wl_en wl_n[6] wl_n[7] DP8TRowDecoderNand3X2
Xdrive[0] vss vdd wl_n[0] wl[0] DP8TWLDrive_26LN100WN26LP200WP_wl2
Xdrive[1] vss vdd wl_n[1] wl[1] DP8TWLDrive_26LN100WN26LP200WP_wl2
Xdrive[2] vss vdd wl_n[2] wl[2] DP8TWLDrive_26LN100WN26LP200WP_wl2
Xdrive[3] vss vdd wl_n[3] wl[3] DP8TWLDrive_26LN100WN26LP200WP_wl2
Xdrive[4] vss vdd wl_n[4] wl[4] DP8TWLDrive_26LN100WN26LP200WP_wl2
Xdrive[5] vss vdd wl_n[5] wl[5] DP8TWLDrive_26LN100WN26LP200WP_wl2
Xdrive[6] vss vdd wl_n[6] wl[6] DP8TWLDrive_26LN100WN26LP200WP_wl2
Xdrive[7] vss vdd wl_n[7] wl[7] DP8TWLDrive_26LN100WN26LP200WP_wl2
.ends DP8TRowDecoderDriverPage_2PD8R_wl2

.subckt DP8TRowDecoder_3_4B_wl2 vss vdd a[0] a[1] a[2] a[3] a[4] a[5] a[6] clk wl_en wl[0] wl[1] wl[2] wl[3] wl[4] wl[5] wl[6] wl[7] wl[8] wl[9] wl[10] wl[11] wl[12] wl[13] wl[14] wl[15] wl[16] wl[17] wl[18] wl[19] wl[20] wl[21] wl[22] wl[23] wl[24] wl[25] wl[26] wl[27] wl[28] wl[29] wl[30] wl[31] wl[32] wl[33] wl[34] wl[35] wl[36] wl[37] wl[38] wl[39] wl[40] wl[41] wl[42] wl[43] wl[44] wl[45] wl[46] wl[47] wl[48] wl[49] wl[50] wl[51] wl[52] wl[53] wl[54] wl[55] wl[56] wl[57] wl[58] wl[59] wl[60] wl[61] wl[62] wl[63] wl[64] wl[65] wl[66] wl[67] wl[68] wl[69] wl[70] wl[71] wl[72] wl[73] wl[74] wl[75] wl[76] wl[77] wl[78] wl[79] wl[80] wl[81] wl[82] wl[83] wl[84] wl[85] wl[86] wl[87] wl[88] wl[89] wl[90] wl[91] wl[92] wl[93] wl[94] wl[95] wl[96] wl[97] wl[98] wl[99] wl[100] wl[101] wl[102] wl[103] wl[104] wl[105] wl[106] wl[107] wl[108] wl[109] wl[110] wl[111] wl[112] wl[113] wl[114] wl[115] wl[116] wl[117] wl[118] wl[119] wl[120] wl[121] wl[122] wl[123] wl[124] wl[125] wl[126] wl[127]
Xpredec vss vdd clk a[0] a[1] a[2] a[3] a[4] a[5] a[6] pd[0][0] pd[0][1] pd[0][2] pd[0][3] pd[0][4] pd[0][5] pd[0][6] pd[0][7] page[0] page[1] page[2] page[3] page[4] page[5] page[6] page[7] page[8] page[9] page[10] page[11] page[12] page[13] page[14] page[15] DP8TRowPredecoders_3_4B_wl2
Xpage[0] vss vdd wl[0] wl[1] wl[2] wl[3] wl[4] wl[5] wl[6] wl[7] pd[0][0] pd[0][1] pd[0][2] pd[0][3] pd[0][4] pd[0][5] pd[0][6] pd[0][7] page[0] wl_en DP8TRowDecoderDriverPage_2PD8R_wl2
Xpage[1] vss vdd wl[8] wl[9] wl[10] wl[11] wl[12] wl[13] wl[14] wl[15] pd[0][0] pd[0][1] pd[0][2] pd[0][3] pd[0][4] pd[0][5] pd[0][6] pd[0][7] page[1] wl_en DP8TRowDecoderDriverPage_2PD8R_wl2
Xpage[2] vss vdd wl[16] wl[17] wl[18] wl[19] wl[20] wl[21] wl[22] wl[23] pd[0][0] pd[0][1] pd[0][2] pd[0][3] pd[0][4] pd[0][5] pd[0][6] pd[0][7] page[2] wl_en DP8TRowDecoderDriverPage_2PD8R_wl2
Xpage[3] vss vdd wl[24] wl[25] wl[26] wl[27] wl[28] wl[29] wl[30] wl[31] pd[0][0] pd[0][1] pd[0][2] pd[0][3] pd[0][4] pd[0][5] pd[0][6] pd[0][7] page[3] wl_en DP8TRowDecoderDriverPage_2PD8R_wl2
Xpage[4] vss vdd wl[32] wl[33] wl[34] wl[35] wl[36] wl[37] wl[38] wl[39] pd[0][0] pd[0][1] pd[0][2] pd[0][3] pd[0][4] pd[0][5] pd[0][6] pd[0][7] page[4] wl_en DP8TRowDecoderDriverPage_2PD8R_wl2
Xpage[5] vss vdd wl[40] wl[41] wl[42] wl[43] wl[44] wl[45] wl[46] wl[47] pd[0][0] pd[0][1] pd[0][2] pd[0][3] pd[0][4] pd[0][5] pd[0][6] pd[0][7] page[5] wl_en DP8TRowDecoderDriverPage_2PD8R_wl2
Xpage[6] vss vdd wl[48] wl[49] wl[50] wl[51] wl[52] wl[53] wl[54] wl[55] pd[0][0] pd[0][1] pd[0][2] pd[0][3] pd[0][4] pd[0][5] pd[0][6] pd[0][7] page[6] wl_en DP8TRowDecoderDriverPage_2PD8R_wl2
Xpage[7] vss vdd wl[56] wl[57] wl[58] wl[59] wl[60] wl[61] wl[62] wl[63] pd[0][0] pd[0][1] pd[0][2] pd[0][3] pd[0][4] pd[0][5] pd[0][6] pd[0][7] page[7] wl_en DP8TRowDecoderDriverPage_2PD8R_wl2
Xpage[8] vss vdd wl[64] wl[65] wl[66] wl[67] wl[68] wl[69] wl[70] wl[71] pd[0][0] pd[0][1] pd[0][2] pd[0][3] pd[0][4] pd[0][5] pd[0][6] pd[0][7] page[8] wl_en DP8TRowDecoderDriverPage_2PD8R_wl2
Xpage[9] vss vdd wl[72] wl[73] wl[74] wl[75] wl[76] wl[77] wl[78] wl[79] pd[0][0] pd[0][1] pd[0][2] pd[0][3] pd[0][4] pd[0][5] pd[0][6] pd[0][7] page[9] wl_en DP8TRowDecoderDriverPage_2PD8R_wl2
Xpage[10] vss vdd wl[80] wl[81] wl[82] wl[83] wl[84] wl[85] wl[86] wl[87] pd[0][0] pd[0][1] pd[0][2] pd[0][3] pd[0][4] pd[0][5] pd[0][6] pd[0][7] page[10] wl_en DP8TRowDecoderDriverPage_2PD8R_wl2
Xpage[11] vss vdd wl[88] wl[89] wl[90] wl[91] wl[92] wl[93] wl[94] wl[95] pd[0][0] pd[0][1] pd[0][2] pd[0][3] pd[0][4] pd[0][5] pd[0][6] pd[0][7] page[11] wl_en DP8TRowDecoderDriverPage_2PD8R_wl2
Xpage[12] vss vdd wl[96] wl[97] wl[98] wl[99] wl[100] wl[101] wl[102] wl[103] pd[0][0] pd[0][1] pd[0][2] pd[0][3] pd[0][4] pd[0][5] pd[0][6] pd[0][7] page[12] wl_en DP8TRowDecoderDriverPage_2PD8R_wl2
Xpage[13] vss vdd wl[104] wl[105] wl[106] wl[107] wl[108] wl[109] wl[110] wl[111] pd[0][0] pd[0][1] pd[0][2] pd[0][3] pd[0][4] pd[0][5] pd[0][6] pd[0][7] page[13] wl_en DP8TRowDecoderDriverPage_2PD8R_wl2
Xpage[14] vss vdd wl[112] wl[113] wl[114] wl[115] wl[116] wl[117] wl[118] wl[119] pd[0][0] pd[0][1] pd[0][2] pd[0][3] pd[0][4] pd[0][5] pd[0][6] pd[0][7] page[14] wl_en DP8TRowDecoderDriverPage_2PD8R_wl2
Xpage[15] vss vdd wl[120] wl[121] wl[122] wl[123] wl[124] wl[125] wl[126] wl[127] pd[0][0] pd[0][1] pd[0][2] pd[0][3] pd[0][4] pd[0][5] pd[0][6] pd[0][7] page[15] wl_en DP8TRowDecoderDriverPage_2PD8R_wl2
Xbulkcon[0] vdd vss DP8TRowDecoderBulkConn
Xbulkcon[1] vdd vss DP8TRowDecoderBulkConn
Xbulkcon[2] vdd vss DP8TRowDecoderBulkConn
Xbulkcon[3] vdd vss DP8TRowDecoderBulkConn
Xbulkcon[4] vdd vss DP8TRowDecoderBulkConn
Xbulkcon[5] vdd vss DP8TRowDecoderBulkConn
Xbulkcon[6] vdd vss DP8TRowDecoderBulkConn
Xbulkcon[7] vdd vss DP8TRowDecoderBulkConn
Xbulkcon[8] vdd vss DP8TRowDecoderBulkConn
.ends DP8TRowDecoder_3_4B_wl2

.subckt DP8TRowPeriphery_3_4_2_wl2 vss vdd clk a[0] a[1] a[2] a[3] a[4] a[5] a[6] a[7] a[8] wl[0] wl[1] wl[2] wl[3] wl[4] wl[5] wl[6] wl[7] wl[8] wl[9] wl[10] wl[11] wl[12] wl[13] wl[14] wl[15] wl[16] wl[17] wl[18] wl[19] wl[20] wl[21] wl[22] wl[23] wl[24] wl[25] wl[26] wl[27] wl[28] wl[29] wl[30] wl[31] wl[32] wl[33] wl[34] wl[35] wl[36] wl[37] wl[38] wl[39] wl[40] wl[41] wl[42] wl[43] wl[44] wl[45] wl[46] wl[47] wl[48] wl[49] wl[50] wl[51] wl[52] wl[53] wl[54] wl[55] wl[56] wl[57] wl[58] wl[59] wl[60] wl[61] wl[62] wl[63] wl[64] wl[65] wl[66] wl[67] wl[68] wl[69] wl[70] wl[71] wl[72] wl[73] wl[74] wl[75] wl[76] wl[77] wl[78] wl[79] wl[80] wl[81] wl[82] wl[83] wl[84] wl[85] wl[86] wl[87] wl[88] wl[89] wl[90] wl[91] wl[92] wl[93] wl[94] wl[95] wl[96] wl[97] wl[98] wl[99] wl[100] wl[101] wl[102] wl[103] wl[104] wl[105] wl[106] wl[107] wl[108] wl[109] wl[110] wl[111] wl[112] wl[113] wl[114] wl[115] wl[116] wl[117] wl[118] wl[119] wl[120] wl[121] wl[122] wl[123] wl[124] wl[125] wl[126] wl[127] mux[0] mux[1] mux[2] mux[3] columnclk precharge_n we_en
Xclkgen vss vdd clk decodeclk columnclk precharge_n wl_en we_en DP8TClockGenerator_8S1R
Xcoldec vss vdd decodeclk a[0] a[1] mux[0] mux[1] mux[2] mux[3] DP8TLatchedDecoder_2A2R
Xrowdec vss vdd a[2] a[3] a[4] a[5] a[6] a[7] a[8] decodeclk wl_en wl[0] wl[1] wl[2] wl[3] wl[4] wl[5] wl[6] wl[7] wl[8] wl[9] wl[10] wl[11] wl[12] wl[13] wl[14] wl[15] wl[16] wl[17] wl[18] wl[19] wl[20] wl[21] wl[22] wl[23] wl[24] wl[25] wl[26] wl[27] wl[28] wl[29] wl[30] wl[31] wl[32] wl[33] wl[34] wl[35] wl[36] wl[37] wl[38] wl[39] wl[40] wl[41] wl[42] wl[43] wl[44] wl[45] wl[46] wl[47] wl[48] wl[49] wl[50] wl[51] wl[52] wl[53] wl[54] wl[55] wl[56] wl[57] wl[58] wl[59] wl[60] wl[61] wl[62] wl[63] wl[64] wl[65] wl[66] wl[67] wl[68] wl[69] wl[70] wl[71] wl[72] wl[73] wl[74] wl[75] wl[76] wl[77] wl[78] wl[79] wl[80] wl[81] wl[82] wl[83] wl[84] wl[85] wl[86] wl[87] wl[88] wl[89] wl[90] wl[91] wl[92] wl[93] wl[94] wl[95] wl[96] wl[97] wl[98] wl[99] wl[100] wl[101] wl[102] wl[103] wl[104] wl[105] wl[106] wl[107] wl[108] wl[109] wl[110] wl[111] wl[112] wl[113] wl[114] wl[115] wl[116] wl[117] wl[118] wl[119] wl[120] wl[121] wl[122] wl[123] wl[124] wl[125] wl[126] wl[127] DP8TRowDecoder_3_4B_wl2
.ends DP8TRowPeriphery_3_4_2_wl2

.subckt DP8TCell wl1 wl2 bl1 bl1_n bl2 bl2_n vdd vss
Xpu1 vdd bit_n bit vdd sg13_lv_pmos l=1.3e-07 w=1.5e-07
Xpd1 bit bit_n vss vss sg13_lv_nmos l=1.3e-07 w=2e-07
Xpu2 vdd bit bit_n vdd sg13_lv_pmos l=1.3e-07 w=1.5e-07
Xpd2 bit_n bit vss vss sg13_lv_nmos l=1.3e-07 w=2e-07
Xpg1 bit wl1 bl1 vss sg13_lv_nmos l=1.3e-07 w=2e-07
Xpg1n bit_n wl1 bl1_n vss sg13_lv_nmos l=1.3e-07 w=2e-07
Xpg2 bit wl2 bl2 vss sg13_lv_nmos l=1.3e-07 w=2e-07
Xpg2n bit_n wl2 bl2_n vss sg13_lv_nmos l=1.3e-07 w=2e-07
.ends DP8TCell

.subckt DP8TArray_2X1 vss vdd wl1[0] wl2[0] wl1[1] wl2[1] bl1[0] bl1_n[0] bl2[0] bl2_n[0]
Xinst0x0 wl1[0] wl2[0] bl1[0] bl1_n[0] bl2[0] bl2_n[0] vdd vss DP8TCell
Xinst1x0 wl1[1] wl2[1] bl1[0] bl1_n[0] bl2[0] bl2_n[0] vdd vss DP8TCell
.ends DP8TArray_2X1

.subckt DP8TArray_2X2 vss vdd wl1[0] wl2[0] wl1[1] wl2[1] bl1[0] bl1_n[0] bl2[0] bl2_n[0] bl1[1] bl1_n[1] bl2[1] bl2_n[1]
Xinst0x0 vss vdd wl1[0] wl2[0] wl1[1] wl2[1] bl1[0] bl1_n[0] bl2[0] bl2_n[0] DP8TArray_2X1
Xinst0x1 vss vdd wl1[0] wl2[0] wl1[1] wl2[1] bl1[1] bl1_n[1] bl2[1] bl2_n[1] DP8TArray_2X1
.ends DP8TArray_2X2

.subckt DP8TArray_4X2 vss vdd wl1[0] wl2[0] wl1[1] wl2[1] wl1[2] wl2[2] wl1[3] wl2[3] bl1[0] bl1_n[0] bl2[0] bl2_n[0] bl1[1] bl1_n[1] bl2[1] bl2_n[1]
Xinst0x0 vss vdd wl1[0] wl2[0] wl1[1] wl2[1] bl1[0] bl1_n[0] bl2[0] bl2_n[0] bl1[1] bl1_n[1] bl2[1] bl2_n[1] DP8TArray_2X2
Xinst1x0 vss vdd wl1[2] wl2[2] wl1[3] wl2[3] bl1[0] bl1_n[0] bl2[0] bl2_n[0] bl1[1] bl1_n[1] bl2[1] bl2_n[1] DP8TArray_2X2
.ends DP8TArray_4X2

.subckt DP8TArray_4X4 vss vdd wl1[0] wl2[0] wl1[1] wl2[1] wl1[2] wl2[2] wl1[3] wl2[3] bl1[0] bl1_n[0] bl2[0] bl2_n[0] bl1[1] bl1_n[1] bl2[1] bl2_n[1] bl1[2] bl1_n[2] bl2[2] bl2_n[2] bl1[3] bl1_n[3] bl2[3] bl2_n[3]
Xinst0x0 vss vdd wl1[0] wl2[0] wl1[1] wl2[1] wl1[2] wl2[2] wl1[3] wl2[3] bl1[0] bl1_n[0] bl2[0] bl2_n[0] bl1[1] bl1_n[1] bl2[1] bl2_n[1] DP8TArray_4X2
Xinst0x1 vss vdd wl1[0] wl2[0] wl1[1] wl2[1] wl1[2] wl2[2] wl1[3] wl2[3] bl1[2] bl1_n[2] bl2[2] bl2_n[2] bl1[3] bl1_n[3] bl2[3] bl2_n[3] DP8TArray_4X2
.ends DP8TArray_4X4

.subckt DP8TArray_8X4 vss vdd wl1[0] wl2[0] wl1[1] wl2[1] wl1[2] wl2[2] wl1[3] wl2[3] wl1[4] wl2[4] wl1[5] wl2[5] wl1[6] wl2[6] wl1[7] wl2[7] bl1[0] bl1_n[0] bl2[0] bl2_n[0] bl1[1] bl1_n[1] bl2[1] bl2_n[1] bl1[2] bl1_n[2] bl2[2] bl2_n[2] bl1[3] bl1_n[3] bl2[3] bl2_n[3]
Xinst0x0 vss vdd wl1[0] wl2[0] wl1[1] wl2[1] wl1[2] wl2[2] wl1[3] wl2[3] bl1[0] bl1_n[0] bl2[0] bl2_n[0] bl1[1] bl1_n[1] bl2[1] bl2_n[1] bl1[2] bl1_n[2] bl2[2] bl2_n[2] bl1[3] bl1_n[3] bl2[3] bl2_n[3] DP8TArray_4X4
Xinst1x0 vss vdd wl1[4] wl2[4] wl1[5] wl2[5] wl1[6] wl2[6] wl1[7] wl2[7] bl1[0] bl1_n[0] bl2[0] bl2_n[0] bl1[1] bl1_n[1] bl2[1] bl2_n[1] bl1[2] bl1_n[2] bl2[2] bl2_n[2] bl1[3] bl1_n[3] bl2[3] bl2_n[3] DP8TArray_4X4
.ends DP8TArray_8X4

.subckt DP8TArray_8X8 vss vdd wl1[0] wl2[0] wl1[1] wl2[1] wl1[2] wl2[2] wl1[3] wl2[3] wl1[4] wl2[4] wl1[5] wl2[5] wl1[6] wl2[6] wl1[7] wl2[7] bl1[0] bl1_n[0] bl2[0] bl2_n[0] bl1[1] bl1_n[1] bl2[1] bl2_n[1] bl1[2] bl1_n[2] bl2[2] bl2_n[2] bl1[3] bl1_n[3] bl2[3] bl2_n[3] bl1[4] bl1_n[4] bl2[4] bl2_n[4] bl1[5] bl1_n[5] bl2[5] bl2_n[5] bl1[6] bl1_n[6] bl2[6] bl2_n[6] bl1[7] bl1_n[7] bl2[7] bl2_n[7]
Xinst0x0 vss vdd wl1[0] wl2[0] wl1[1] wl2[1] wl1[2] wl2[2] wl1[3] wl2[3] wl1[4] wl2[4] wl1[5] wl2[5] wl1[6] wl2[6] wl1[7] wl2[7] bl1[0] bl1_n[0] bl2[0] bl2_n[0] bl1[1] bl1_n[1] bl2[1] bl2_n[1] bl1[2] bl1_n[2] bl2[2] bl2_n[2] bl1[3] bl1_n[3] bl2[3] bl2_n[3] DP8TArray_8X4
Xinst0x1 vss vdd wl1[0] wl2[0] wl1[1] wl2[1] wl1[2] wl2[2] wl1[3] wl2[3] wl1[4] wl2[4] wl1[5] wl2[5] wl1[6] wl2[6] wl1[7] wl2[7] bl1[4] bl1_n[4] bl2[4] bl2_n[4] bl1[5] bl1_n[5] bl2[5] bl2_n[5] bl1[6] bl1_n[6] bl2[6] bl2_n[6] bl1[7] bl1_n[7] bl2[7] bl2_n[7] DP8TArray_8X4
.ends DP8TArray_8X8

.subckt DP8TArray_16X8 vss vdd wl1[0] wl2[0] wl1[1] wl2[1] wl1[2] wl2[2] wl1[3] wl2[3] wl1[4] wl2[4] wl1[5] wl2[5] wl1[6] wl2[6] wl1[7] wl2[7] wl1[8] wl2[8] wl1[9] wl2[9] wl1[10] wl2[10] wl1[11] wl2[11] wl1[12] wl2[12] wl1[13] wl2[13] wl1[14] wl2[14] wl1[15] wl2[15] bl1[0] bl1_n[0] bl2[0] bl2_n[0] bl1[1] bl1_n[1] bl2[1] bl2_n[1] bl1[2] bl1_n[2] bl2[2] bl2_n[2] bl1[3] bl1_n[3] bl2[3] bl2_n[3] bl1[4] bl1_n[4] bl2[4] bl2_n[4] bl1[5] bl1_n[5] bl2[5] bl2_n[5] bl1[6] bl1_n[6] bl2[6] bl2_n[6] bl1[7] bl1_n[7] bl2[7] bl2_n[7]
Xinst0x0 vss vdd wl1[0] wl2[0] wl1[1] wl2[1] wl1[2] wl2[2] wl1[3] wl2[3] wl1[4] wl2[4] wl1[5] wl2[5] wl1[6] wl2[6] wl1[7] wl2[7] bl1[0] bl1_n[0] bl2[0] bl2_n[0] bl1[1] bl1_n[1] bl2[1] bl2_n[1] bl1[2] bl1_n[2] bl2[2] bl2_n[2] bl1[3] bl1_n[3] bl2[3] bl2_n[3] bl1[4] bl1_n[4] bl2[4] bl2_n[4] bl1[5] bl1_n[5] bl2[5] bl2_n[5] bl1[6] bl1_n[6] bl2[6] bl2_n[6] bl1[7] bl1_n[7] bl2[7] bl2_n[7] DP8TArray_8X8
Xinst1x0 vss vdd wl1[8] wl2[8] wl1[9] wl2[9] wl1[10] wl2[10] wl1[11] wl2[11] wl1[12] wl2[12] wl1[13] wl2[13] wl1[14] wl2[14] wl1[15] wl2[15] bl1[0] bl1_n[0] bl2[0] bl2_n[0] bl1[1] bl1_n[1] bl2[1] bl2_n[1] bl1[2] bl1_n[2] bl2[2] bl2_n[2] bl1[3] bl1_n[3] bl2[3] bl2_n[3] bl1[4] bl1_n[4] bl2[4] bl2_n[4] bl1[5] bl1_n[5] bl2[5] bl2_n[5] bl1[6] bl1_n[6] bl2[6] bl2_n[6] bl1[7] bl1_n[7] bl2[7] bl2_n[7] DP8TArray_8X8
.ends DP8TArray_16X8

.subckt DP8TArray_16X16 vss vdd wl1[0] wl2[0] wl1[1] wl2[1] wl1[2] wl2[2] wl1[3] wl2[3] wl1[4] wl2[4] wl1[5] wl2[5] wl1[6] wl2[6] wl1[7] wl2[7] wl1[8] wl2[8] wl1[9] wl2[9] wl1[10] wl2[10] wl1[11] wl2[11] wl1[12] wl2[12] wl1[13] wl2[13] wl1[14] wl2[14] wl1[15] wl2[15] bl1[0] bl1_n[0] bl2[0] bl2_n[0] bl1[1] bl1_n[1] bl2[1] bl2_n[1] bl1[2] bl1_n[2] bl2[2] bl2_n[2] bl1[3] bl1_n[3] bl2[3] bl2_n[3] bl1[4] bl1_n[4] bl2[4] bl2_n[4] bl1[5] bl1_n[5] bl2[5] bl2_n[5] bl1[6] bl1_n[6] bl2[6] bl2_n[6] bl1[7] bl1_n[7] bl2[7] bl2_n[7] bl1[8] bl1_n[8] bl2[8] bl2_n[8] bl1[9] bl1_n[9] bl2[9] bl2_n[9] bl1[10] bl1_n[10] bl2[10] bl2_n[10] bl1[11] bl1_n[11] bl2[11] bl2_n[11] bl1[12] bl1_n[12] bl2[12] bl2_n[12] bl1[13] bl1_n[13] bl2[13] bl2_n[13] bl1[14] bl1_n[14] bl2[14] bl2_n[14] bl1[15] bl1_n[15] bl2[15] bl2_n[15]
Xinst0x0 vss vdd wl1[0] wl2[0] wl1[1] wl2[1] wl1[2] wl2[2] wl1[3] wl2[3] wl1[4] wl2[4] wl1[5] wl2[5] wl1[6] wl2[6] wl1[7] wl2[7] wl1[8] wl2[8] wl1[9] wl2[9] wl1[10] wl2[10] wl1[11] wl2[11] wl1[12] wl2[12] wl1[13] wl2[13] wl1[14] wl2[14] wl1[15] wl2[15] bl1[0] bl1_n[0] bl2[0] bl2_n[0] bl1[1] bl1_n[1] bl2[1] bl2_n[1] bl1[2] bl1_n[2] bl2[2] bl2_n[2] bl1[3] bl1_n[3] bl2[3] bl2_n[3] bl1[4] bl1_n[4] bl2[4] bl2_n[4] bl1[5] bl1_n[5] bl2[5] bl2_n[5] bl1[6] bl1_n[6] bl2[6] bl2_n[6] bl1[7] bl1_n[7] bl2[7] bl2_n[7] DP8TArray_16X8
Xinst0x1 vss vdd wl1[0] wl2[0] wl1[1] wl2[1] wl1[2] wl2[2] wl1[3] wl2[3] wl1[4] wl2[4] wl1[5] wl2[5] wl1[6] wl2[6] wl1[7] wl2[7] wl1[8] wl2[8] wl1[9] wl2[9] wl1[10] wl2[10] wl1[11] wl2[11] wl1[12] wl2[12] wl1[13] wl2[13] wl1[14] wl2[14] wl1[15] wl2[15] bl1[8] bl1_n[8] bl2[8] bl2_n[8] bl1[9] bl1_n[9] bl2[9] bl2_n[9] bl1[10] bl1_n[10] bl2[10] bl2_n[10] bl1[11] bl1_n[11] bl2[11] bl2_n[11] bl1[12] bl1_n[12] bl2[12] bl2_n[12] bl1[13] bl1_n[13] bl2[13] bl2_n[13] bl1[14] bl1_n[14] bl2[14] bl2_n[14] bl1[15] bl1_n[15] bl2[15] bl2_n[15] DP8TArray_16X8
.ends DP8TArray_16X16

.subckt DP8TArray_16X32 vss vdd wl1[0] wl2[0] wl1[1] wl2[1] wl1[2] wl2[2] wl1[3] wl2[3] wl1[4] wl2[4] wl1[5] wl2[5] wl1[6] wl2[6] wl1[7] wl2[7] wl1[8] wl2[8] wl1[9] wl2[9] wl1[10] wl2[10] wl1[11] wl2[11] wl1[12] wl2[12] wl1[13] wl2[13] wl1[14] wl2[14] wl1[15] wl2[15] bl1[0] bl1_n[0] bl2[0] bl2_n[0] bl1[1] bl1_n[1] bl2[1] bl2_n[1] bl1[2] bl1_n[2] bl2[2] bl2_n[2] bl1[3] bl1_n[3] bl2[3] bl2_n[3] bl1[4] bl1_n[4] bl2[4] bl2_n[4] bl1[5] bl1_n[5] bl2[5] bl2_n[5] bl1[6] bl1_n[6] bl2[6] bl2_n[6] bl1[7] bl1_n[7] bl2[7] bl2_n[7] bl1[8] bl1_n[8] bl2[8] bl2_n[8] bl1[9] bl1_n[9] bl2[9] bl2_n[9] bl1[10] bl1_n[10] bl2[10] bl2_n[10] bl1[11] bl1_n[11] bl2[11] bl2_n[11] bl1[12] bl1_n[12] bl2[12] bl2_n[12] bl1[13] bl1_n[13] bl2[13] bl2_n[13] bl1[14] bl1_n[14] bl2[14] bl2_n[14] bl1[15] bl1_n[15] bl2[15] bl2_n[15] bl1[16] bl1_n[16] bl2[16] bl2_n[16] bl1[17] bl1_n[17] bl2[17] bl2_n[17] bl1[18] bl1_n[18] bl2[18] bl2_n[18] bl1[19] bl1_n[19] bl2[19] bl2_n[19] bl1[20] bl1_n[20] bl2[20] bl2_n[20] bl1[21] bl1_n[21] bl2[21] bl2_n[21] bl1[22] bl1_n[22] bl2[22] bl2_n[22] bl1[23] bl1_n[23] bl2[23] bl2_n[23] bl1[24] bl1_n[24] bl2[24] bl2_n[24] bl1[25] bl1_n[25] bl2[25] bl2_n[25] bl1[26] bl1_n[26] bl2[26] bl2_n[26] bl1[27] bl1_n[27] bl2[27] bl2_n[27] bl1[28] bl1_n[28] bl2[28] bl2_n[28] bl1[29] bl1_n[29] bl2[29] bl2_n[29] bl1[30] bl1_n[30] bl2[30] bl2_n[30] bl1[31] bl1_n[31] bl2[31] bl2_n[31]
Xinst0x0 vss vdd wl1[0] wl2[0] wl1[1] wl2[1] wl1[2] wl2[2] wl1[3] wl2[3] wl1[4] wl2[4] wl1[5] wl2[5] wl1[6] wl2[6] wl1[7] wl2[7] wl1[8] wl2[8] wl1[9] wl2[9] wl1[10] wl2[10] wl1[11] wl2[11] wl1[12] wl2[12] wl1[13] wl2[13] wl1[14] wl2[14] wl1[15] wl2[15] bl1[0] bl1_n[0] bl2[0] bl2_n[0] bl1[1] bl1_n[1] bl2[1] bl2_n[1] bl1[2] bl1_n[2] bl2[2] bl2_n[2] bl1[3] bl1_n[3] bl2[3] bl2_n[3] bl1[4] bl1_n[4] bl2[4] bl2_n[4] bl1[5] bl1_n[5] bl2[5] bl2_n[5] bl1[6] bl1_n[6] bl2[6] bl2_n[6] bl1[7] bl1_n[7] bl2[7] bl2_n[7] bl1[8] bl1_n[8] bl2[8] bl2_n[8] bl1[9] bl1_n[9] bl2[9] bl2_n[9] bl1[10] bl1_n[10] bl2[10] bl2_n[10] bl1[11] bl1_n[11] bl2[11] bl2_n[11] bl1[12] bl1_n[12] bl2[12] bl2_n[12] bl1[13] bl1_n[13] bl2[13] bl2_n[13] bl1[14] bl1_n[14] bl2[14] bl2_n[14] bl1[15] bl1_n[15] bl2[15] bl2_n[15] DP8TArray_16X16
Xinst0x1 vss vdd wl1[0] wl2[0] wl1[1] wl2[1] wl1[2] wl2[2] wl1[3] wl2[3] wl1[4] wl2[4] wl1[5] wl2[5] wl1[6] wl2[6] wl1[7] wl2[7] wl1[8] wl2[8] wl1[9] wl2[9] wl1[10] wl2[10] wl1[11] wl2[11] wl1[12] wl2[12] wl1[13] wl2[13] wl1[14] wl2[14] wl1[15] wl2[15] bl1[16] bl1_n[16] bl2[16] bl2_n[16] bl1[17] bl1_n[17] bl2[17] bl2_n[17] bl1[18] bl1_n[18] bl2[18] bl2_n[18] bl1[19] bl1_n[19] bl2[19] bl2_n[19] bl1[20] bl1_n[20] bl2[20] bl2_n[20] bl1[21] bl1_n[21] bl2[21] bl2_n[21] bl1[22] bl1_n[22] bl2[22] bl2_n[22] bl1[23] bl1_n[23] bl2[23] bl2_n[23] bl1[24] bl1_n[24] bl2[24] bl2_n[24] bl1[25] bl1_n[25] bl2[25] bl2_n[25] bl1[26] bl1_n[26] bl2[26] bl2_n[26] bl1[27] bl1_n[27] bl2[27] bl2_n[27] bl1[28] bl1_n[28] bl2[28] bl2_n[28] bl1[29] bl1_n[29] bl2[29] bl2_n[29] bl1[30] bl1_n[30] bl2[30] bl2_n[30] bl1[31] bl1_n[31] bl2[31] bl2_n[31] DP8TArray_16X16
.ends DP8TArray_16X32

.subckt DP8TBulkConn vdd vss bl1 bl2 bl1_n bl2_n
.ends DP8TBulkConn

.subckt DP8TBulkConnRow_2 vss vdd bl1[0] bl1_n[0] bl2[0] bl2_n[0] bl1[1] bl1_n[1] bl2[1] bl2_n[1]
Xinst0 vdd vss bl1[0] bl2[0] bl1_n[0] bl2_n[0] DP8TBulkConn
Xinst1 vdd vss bl1[1] bl2[1] bl1_n[1] bl2_n[1] DP8TBulkConn
.ends DP8TBulkConnRow_2

.subckt DP8TBulkConnRow_4 vss vdd bl1[0] bl1_n[0] bl2[0] bl2_n[0] bl1[1] bl1_n[1] bl2[1] bl2_n[1] bl1[2] bl1_n[2] bl2[2] bl2_n[2] bl1[3] bl1_n[3] bl2[3] bl2_n[3]
Xinst0 vss vdd bl1[0] bl1_n[0] bl2[0] bl2_n[0] bl1[1] bl1_n[1] bl2[1] bl2_n[1] DP8TBulkConnRow_2
Xinst1 vss vdd bl1[2] bl1_n[2] bl2[2] bl2_n[2] bl1[3] bl1_n[3] bl2[3] bl2_n[3] DP8TBulkConnRow_2
.ends DP8TBulkConnRow_4

.subckt DP8TBulkConnRow_8 vss vdd bl1[0] bl1_n[0] bl2[0] bl2_n[0] bl1[1] bl1_n[1] bl2[1] bl2_n[1] bl1[2] bl1_n[2] bl2[2] bl2_n[2] bl1[3] bl1_n[3] bl2[3] bl2_n[3] bl1[4] bl1_n[4] bl2[4] bl2_n[4] bl1[5] bl1_n[5] bl2[5] bl2_n[5] bl1[6] bl1_n[6] bl2[6] bl2_n[6] bl1[7] bl1_n[7] bl2[7] bl2_n[7]
Xinst0 vss vdd bl1[0] bl1_n[0] bl2[0] bl2_n[0] bl1[1] bl1_n[1] bl2[1] bl2_n[1] bl1[2] bl1_n[2] bl2[2] bl2_n[2] bl1[3] bl1_n[3] bl2[3] bl2_n[3] DP8TBulkConnRow_4
Xinst1 vss vdd bl1[4] bl1_n[4] bl2[4] bl2_n[4] bl1[5] bl1_n[5] bl2[5] bl2_n[5] bl1[6] bl1_n[6] bl2[6] bl2_n[6] bl1[7] bl1_n[7] bl2[7] bl2_n[7] DP8TBulkConnRow_4
.ends DP8TBulkConnRow_8

.subckt DP8TBulkConnRow_16 vss vdd bl1[0] bl1_n[0] bl2[0] bl2_n[0] bl1[1] bl1_n[1] bl2[1] bl2_n[1] bl1[2] bl1_n[2] bl2[2] bl2_n[2] bl1[3] bl1_n[3] bl2[3] bl2_n[3] bl1[4] bl1_n[4] bl2[4] bl2_n[4] bl1[5] bl1_n[5] bl2[5] bl2_n[5] bl1[6] bl1_n[6] bl2[6] bl2_n[6] bl1[7] bl1_n[7] bl2[7] bl2_n[7] bl1[8] bl1_n[8] bl2[8] bl2_n[8] bl1[9] bl1_n[9] bl2[9] bl2_n[9] bl1[10] bl1_n[10] bl2[10] bl2_n[10] bl1[11] bl1_n[11] bl2[11] bl2_n[11] bl1[12] bl1_n[12] bl2[12] bl2_n[12] bl1[13] bl1_n[13] bl2[13] bl2_n[13] bl1[14] bl1_n[14] bl2[14] bl2_n[14] bl1[15] bl1_n[15] bl2[15] bl2_n[15]
Xinst0 vss vdd bl1[0] bl1_n[0] bl2[0] bl2_n[0] bl1[1] bl1_n[1] bl2[1] bl2_n[1] bl1[2] bl1_n[2] bl2[2] bl2_n[2] bl1[3] bl1_n[3] bl2[3] bl2_n[3] bl1[4] bl1_n[4] bl2[4] bl2_n[4] bl1[5] bl1_n[5] bl2[5] bl2_n[5] bl1[6] bl1_n[6] bl2[6] bl2_n[6] bl1[7] bl1_n[7] bl2[7] bl2_n[7] DP8TBulkConnRow_8
Xinst1 vss vdd bl1[8] bl1_n[8] bl2[8] bl2_n[8] bl1[9] bl1_n[9] bl2[9] bl2_n[9] bl1[10] bl1_n[10] bl2[10] bl2_n[10] bl1[11] bl1_n[11] bl2[11] bl2_n[11] bl1[12] bl1_n[12] bl2[12] bl2_n[12] bl1[13] bl1_n[13] bl2[13] bl2_n[13] bl1[14] bl1_n[14] bl2[14] bl2_n[14] bl1[15] bl1_n[15] bl2[15] bl2_n[15] DP8TBulkConnRow_8
.ends DP8TBulkConnRow_16

.subckt DP8TBulkConnRow_32 vss vdd bl1[0] bl1_n[0] bl2[0] bl2_n[0] bl1[1] bl1_n[1] bl2[1] bl2_n[1] bl1[2] bl1_n[2] bl2[2] bl2_n[2] bl1[3] bl1_n[3] bl2[3] bl2_n[3] bl1[4] bl1_n[4] bl2[4] bl2_n[4] bl1[5] bl1_n[5] bl2[5] bl2_n[5] bl1[6] bl1_n[6] bl2[6] bl2_n[6] bl1[7] bl1_n[7] bl2[7] bl2_n[7] bl1[8] bl1_n[8] bl2[8] bl2_n[8] bl1[9] bl1_n[9] bl2[9] bl2_n[9] bl1[10] bl1_n[10] bl2[10] bl2_n[10] bl1[11] bl1_n[11] bl2[11] bl2_n[11] bl1[12] bl1_n[12] bl2[12] bl2_n[12] bl1[13] bl1_n[13] bl2[13] bl2_n[13] bl1[14] bl1_n[14] bl2[14] bl2_n[14] bl1[15] bl1_n[15] bl2[15] bl2_n[15] bl1[16] bl1_n[16] bl2[16] bl2_n[16] bl1[17] bl1_n[17] bl2[17] bl2_n[17] bl1[18] bl1_n[18] bl2[18] bl2_n[18] bl1[19] bl1_n[19] bl2[19] bl2_n[19] bl1[20] bl1_n[20] bl2[20] bl2_n[20] bl1[21] bl1_n[21] bl2[21] bl2_n[21] bl1[22] bl1_n[22] bl2[22] bl2_n[22] bl1[23] bl1_n[23] bl2[23] bl2_n[23] bl1[24] bl1_n[24] bl2[24] bl2_n[24] bl1[25] bl1_n[25] bl2[25] bl2_n[25] bl1[26] bl1_n[26] bl2[26] bl2_n[26] bl1[27] bl1_n[27] bl2[27] bl2_n[27] bl1[28] bl1_n[28] bl2[28] bl2_n[28] bl1[29] bl1_n[29] bl2[29] bl2_n[29] bl1[30] bl1_n[30] bl2[30] bl2_n[30] bl1[31] bl1_n[31] bl2[31] bl2_n[31]
Xinst0 vss vdd bl1[0] bl1_n[0] bl2[0] bl2_n[0] bl1[1] bl1_n[1] bl2[1] bl2_n[1] bl1[2] bl1_n[2] bl2[2] bl2_n[2] bl1[3] bl1_n[3] bl2[3] bl2_n[3] bl1[4] bl1_n[4] bl2[4] bl2_n[4] bl1[5] bl1_n[5] bl2[5] bl2_n[5] bl1[6] bl1_n[6] bl2[6] bl2_n[6] bl1[7] bl1_n[7] bl2[7] bl2_n[7] bl1[8] bl1_n[8] bl2[8] bl2_n[8] bl1[9] bl1_n[9] bl2[9] bl2_n[9] bl1[10] bl1_n[10] bl2[10] bl2_n[10] bl1[11] bl1_n[11] bl2[11] bl2_n[11] bl1[12] bl1_n[12] bl2[12] bl2_n[12] bl1[13] bl1_n[13] bl2[13] bl2_n[13] bl1[14] bl1_n[14] bl2[14] bl2_n[14] bl1[15] bl1_n[15] bl2[15] bl2_n[15] DP8TBulkConnRow_16
Xinst1 vss vdd bl1[16] bl1_n[16] bl2[16] bl2_n[16] bl1[17] bl1_n[17] bl2[17] bl2_n[17] bl1[18] bl1_n[18] bl2[18] bl2_n[18] bl1[19] bl1_n[19] bl2[19] bl2_n[19] bl1[20] bl1_n[20] bl2[20] bl2_n[20] bl1[21] bl1_n[21] bl2[21] bl2_n[21] bl1[22] bl1_n[22] bl2[22] bl2_n[22] bl1[23] bl1_n[23] bl2[23] bl2_n[23] bl1[24] bl1_n[24] bl2[24] bl2_n[24] bl1[25] bl1_n[25] bl2[25] bl2_n[25] bl1[26] bl1_n[26] bl2[26] bl2_n[26] bl1[27] bl1_n[27] bl2[27] bl2_n[27] bl1[28] bl1_n[28] bl2[28] bl2_n[28] bl1[29] bl1_n[29] bl2[29] bl2_n[29] bl1[30] bl1_n[30] bl2[30] bl2_n[30] bl1[31] bl1_n[31] bl2[31] bl2_n[31] DP8TBulkConnRow_16
.ends DP8TBulkConnRow_32

.subckt DP8TArray_32X32 vss vdd wl1[0] wl2[0] wl1[1] wl2[1] wl1[2] wl2[2] wl1[3] wl2[3] wl1[4] wl2[4] wl1[5] wl2[5] wl1[6] wl2[6] wl1[7] wl2[7] wl1[8] wl2[8] wl1[9] wl2[9] wl1[10] wl2[10] wl1[11] wl2[11] wl1[12] wl2[12] wl1[13] wl2[13] wl1[14] wl2[14] wl1[15] wl2[15] wl1[16] wl2[16] wl1[17] wl2[17] wl1[18] wl2[18] wl1[19] wl2[19] wl1[20] wl2[20] wl1[21] wl2[21] wl1[22] wl2[22] wl1[23] wl2[23] wl1[24] wl2[24] wl1[25] wl2[25] wl1[26] wl2[26] wl1[27] wl2[27] wl1[28] wl2[28] wl1[29] wl2[29] wl1[30] wl2[30] wl1[31] wl2[31] bl1[0] bl1_n[0] bl2[0] bl2_n[0] bl1[1] bl1_n[1] bl2[1] bl2_n[1] bl1[2] bl1_n[2] bl2[2] bl2_n[2] bl1[3] bl1_n[3] bl2[3] bl2_n[3] bl1[4] bl1_n[4] bl2[4] bl2_n[4] bl1[5] bl1_n[5] bl2[5] bl2_n[5] bl1[6] bl1_n[6] bl2[6] bl2_n[6] bl1[7] bl1_n[7] bl2[7] bl2_n[7] bl1[8] bl1_n[8] bl2[8] bl2_n[8] bl1[9] bl1_n[9] bl2[9] bl2_n[9] bl1[10] bl1_n[10] bl2[10] bl2_n[10] bl1[11] bl1_n[11] bl2[11] bl2_n[11] bl1[12] bl1_n[12] bl2[12] bl2_n[12] bl1[13] bl1_n[13] bl2[13] bl2_n[13] bl1[14] bl1_n[14] bl2[14] bl2_n[14] bl1[15] bl1_n[15] bl2[15] bl2_n[15] bl1[16] bl1_n[16] bl2[16] bl2_n[16] bl1[17] bl1_n[17] bl2[17] bl2_n[17] bl1[18] bl1_n[18] bl2[18] bl2_n[18] bl1[19] bl1_n[19] bl2[19] bl2_n[19] bl1[20] bl1_n[20] bl2[20] bl2_n[20] bl1[21] bl1_n[21] bl2[21] bl2_n[21] bl1[22] bl1_n[22] bl2[22] bl2_n[22] bl1[23] bl1_n[23] bl2[23] bl2_n[23] bl1[24] bl1_n[24] bl2[24] bl2_n[24] bl1[25] bl1_n[25] bl2[25] bl2_n[25] bl1[26] bl1_n[26] bl2[26] bl2_n[26] bl1[27] bl1_n[27] bl2[27] bl2_n[27] bl1[28] bl1_n[28] bl2[28] bl2_n[28] bl1[29] bl1_n[29] bl2[29] bl2_n[29] bl1[30] bl1_n[30] bl2[30] bl2_n[30] bl1[31] bl1_n[31] bl2[31] bl2_n[31]
Xinst0x0 vss vdd wl1[0] wl2[0] wl1[1] wl2[1] wl1[2] wl2[2] wl1[3] wl2[3] wl1[4] wl2[4] wl1[5] wl2[5] wl1[6] wl2[6] wl1[7] wl2[7] wl1[8] wl2[8] wl1[9] wl2[9] wl1[10] wl2[10] wl1[11] wl2[11] wl1[12] wl2[12] wl1[13] wl2[13] wl1[14] wl2[14] wl1[15] wl2[15] bl1[0] bl1_n[0] bl2[0] bl2_n[0] bl1[1] bl1_n[1] bl2[1] bl2_n[1] bl1[2] bl1_n[2] bl2[2] bl2_n[2] bl1[3] bl1_n[3] bl2[3] bl2_n[3] bl1[4] bl1_n[4] bl2[4] bl2_n[4] bl1[5] bl1_n[5] bl2[5] bl2_n[5] bl1[6] bl1_n[6] bl2[6] bl2_n[6] bl1[7] bl1_n[7] bl2[7] bl2_n[7] bl1[8] bl1_n[8] bl2[8] bl2_n[8] bl1[9] bl1_n[9] bl2[9] bl2_n[9] bl1[10] bl1_n[10] bl2[10] bl2_n[10] bl1[11] bl1_n[11] bl2[11] bl2_n[11] bl1[12] bl1_n[12] bl2[12] bl2_n[12] bl1[13] bl1_n[13] bl2[13] bl2_n[13] bl1[14] bl1_n[14] bl2[14] bl2_n[14] bl1[15] bl1_n[15] bl2[15] bl2_n[15] bl1[16] bl1_n[16] bl2[16] bl2_n[16] bl1[17] bl1_n[17] bl2[17] bl2_n[17] bl1[18] bl1_n[18] bl2[18] bl2_n[18] bl1[19] bl1_n[19] bl2[19] bl2_n[19] bl1[20] bl1_n[20] bl2[20] bl2_n[20] bl1[21] bl1_n[21] bl2[21] bl2_n[21] bl1[22] bl1_n[22] bl2[22] bl2_n[22] bl1[23] bl1_n[23] bl2[23] bl2_n[23] bl1[24] bl1_n[24] bl2[24] bl2_n[24] bl1[25] bl1_n[25] bl2[25] bl2_n[25] bl1[26] bl1_n[26] bl2[26] bl2_n[26] bl1[27] bl1_n[27] bl2[27] bl2_n[27] bl1[28] bl1_n[28] bl2[28] bl2_n[28] bl1[29] bl1_n[29] bl2[29] bl2_n[29] bl1[30] bl1_n[30] bl2[30] bl2_n[30] bl1[31] bl1_n[31] bl2[31] bl2_n[31] DP8TArray_16X32
Xinst1x0 vss vdd wl1[16] wl2[16] wl1[17] wl2[17] wl1[18] wl2[18] wl1[19] wl2[19] wl1[20] wl2[20] wl1[21] wl2[21] wl1[22] wl2[22] wl1[23] wl2[23] wl1[24] wl2[24] wl1[25] wl2[25] wl1[26] wl2[26] wl1[27] wl2[27] wl1[28] wl2[28] wl1[29] wl2[29] wl1[30] wl2[30] wl1[31] wl2[31] bl1[0] bl1_n[0] bl2[0] bl2_n[0] bl1[1] bl1_n[1] bl2[1] bl2_n[1] bl1[2] bl1_n[2] bl2[2] bl2_n[2] bl1[3] bl1_n[3] bl2[3] bl2_n[3] bl1[4] bl1_n[4] bl2[4] bl2_n[4] bl1[5] bl1_n[5] bl2[5] bl2_n[5] bl1[6] bl1_n[6] bl2[6] bl2_n[6] bl1[7] bl1_n[7] bl2[7] bl2_n[7] bl1[8] bl1_n[8] bl2[8] bl2_n[8] bl1[9] bl1_n[9] bl2[9] bl2_n[9] bl1[10] bl1_n[10] bl2[10] bl2_n[10] bl1[11] bl1_n[11] bl2[11] bl2_n[11] bl1[12] bl1_n[12] bl2[12] bl2_n[12] bl1[13] bl1_n[13] bl2[13] bl2_n[13] bl1[14] bl1_n[14] bl2[14] bl2_n[14] bl1[15] bl1_n[15] bl2[15] bl2_n[15] bl1[16] bl1_n[16] bl2[16] bl2_n[16] bl1[17] bl1_n[17] bl2[17] bl2_n[17] bl1[18] bl1_n[18] bl2[18] bl2_n[18] bl1[19] bl1_n[19] bl2[19] bl2_n[19] bl1[20] bl1_n[20] bl2[20] bl2_n[20] bl1[21] bl1_n[21] bl2[21] bl2_n[21] bl1[22] bl1_n[22] bl2[22] bl2_n[22] bl1[23] bl1_n[23] bl2[23] bl2_n[23] bl1[24] bl1_n[24] bl2[24] bl2_n[24] bl1[25] bl1_n[25] bl2[25] bl2_n[25] bl1[26] bl1_n[26] bl2[26] bl2_n[26] bl1[27] bl1_n[27] bl2[27] bl2_n[27] bl1[28] bl1_n[28] bl2[28] bl2_n[28] bl1[29] bl1_n[29] bl2[29] bl2_n[29] bl1[30] bl1_n[30] bl2[30] bl2_n[30] bl1[31] bl1_n[31] bl2[31] bl2_n[31] DP8TArray_16X32
Xbcrow vss vdd bl1[0] bl1_n[0] bl2[0] bl2_n[0] bl1[1] bl1_n[1] bl2[1] bl2_n[1] bl1[2] bl1_n[2] bl2[2] bl2_n[2] bl1[3] bl1_n[3] bl2[3] bl2_n[3] bl1[4] bl1_n[4] bl2[4] bl2_n[4] bl1[5] bl1_n[5] bl2[5] bl2_n[5] bl1[6] bl1_n[6] bl2[6] bl2_n[6] bl1[7] bl1_n[7] bl2[7] bl2_n[7] bl1[8] bl1_n[8] bl2[8] bl2_n[8] bl1[9] bl1_n[9] bl2[9] bl2_n[9] bl1[10] bl1_n[10] bl2[10] bl2_n[10] bl1[11] bl1_n[11] bl2[11] bl2_n[11] bl1[12] bl1_n[12] bl2[12] bl2_n[12] bl1[13] bl1_n[13] bl2[13] bl2_n[13] bl1[14] bl1_n[14] bl2[14] bl2_n[14] bl1[15] bl1_n[15] bl2[15] bl2_n[15] bl1[16] bl1_n[16] bl2[16] bl2_n[16] bl1[17] bl1_n[17] bl2[17] bl2_n[17] bl1[18] bl1_n[18] bl2[18] bl2_n[18] bl1[19] bl1_n[19] bl2[19] bl2_n[19] bl1[20] bl1_n[20] bl2[20] bl2_n[20] bl1[21] bl1_n[21] bl2[21] bl2_n[21] bl1[22] bl1_n[22] bl2[22] bl2_n[22] bl1[23] bl1_n[23] bl2[23] bl2_n[23] bl1[24] bl1_n[24] bl2[24] bl2_n[24] bl1[25] bl1_n[25] bl2[25] bl2_n[25] bl1[26] bl1_n[26] bl2[26] bl2_n[26] bl1[27] bl1_n[27] bl2[27] bl2_n[27] bl1[28] bl1_n[28] bl2[28] bl2_n[28] bl1[29] bl1_n[29] bl2[29] bl2_n[29] bl1[30] bl1_n[30] bl2[30] bl2_n[30] bl1[31] bl1_n[31] bl2[31] bl2_n[31] DP8TBulkConnRow_32
.ends DP8TArray_32X32

.subckt DP8TArray_64X32 vss vdd wl1[0] wl2[0] wl1[1] wl2[1] wl1[2] wl2[2] wl1[3] wl2[3] wl1[4] wl2[4] wl1[5] wl2[5] wl1[6] wl2[6] wl1[7] wl2[7] wl1[8] wl2[8] wl1[9] wl2[9] wl1[10] wl2[10] wl1[11] wl2[11] wl1[12] wl2[12] wl1[13] wl2[13] wl1[14] wl2[14] wl1[15] wl2[15] wl1[16] wl2[16] wl1[17] wl2[17] wl1[18] wl2[18] wl1[19] wl2[19] wl1[20] wl2[20] wl1[21] wl2[21] wl1[22] wl2[22] wl1[23] wl2[23] wl1[24] wl2[24] wl1[25] wl2[25] wl1[26] wl2[26] wl1[27] wl2[27] wl1[28] wl2[28] wl1[29] wl2[29] wl1[30] wl2[30] wl1[31] wl2[31] wl1[32] wl2[32] wl1[33] wl2[33] wl1[34] wl2[34] wl1[35] wl2[35] wl1[36] wl2[36] wl1[37] wl2[37] wl1[38] wl2[38] wl1[39] wl2[39] wl1[40] wl2[40] wl1[41] wl2[41] wl1[42] wl2[42] wl1[43] wl2[43] wl1[44] wl2[44] wl1[45] wl2[45] wl1[46] wl2[46] wl1[47] wl2[47] wl1[48] wl2[48] wl1[49] wl2[49] wl1[50] wl2[50] wl1[51] wl2[51] wl1[52] wl2[52] wl1[53] wl2[53] wl1[54] wl2[54] wl1[55] wl2[55] wl1[56] wl2[56] wl1[57] wl2[57] wl1[58] wl2[58] wl1[59] wl2[59] wl1[60] wl2[60] wl1[61] wl2[61] wl1[62] wl2[62] wl1[63] wl2[63] bl1[0] bl1_n[0] bl2[0] bl2_n[0] bl1[1] bl1_n[1] bl2[1] bl2_n[1] bl1[2] bl1_n[2] bl2[2] bl2_n[2] bl1[3] bl1_n[3] bl2[3] bl2_n[3] bl1[4] bl1_n[4] bl2[4] bl2_n[4] bl1[5] bl1_n[5] bl2[5] bl2_n[5] bl1[6] bl1_n[6] bl2[6] bl2_n[6] bl1[7] bl1_n[7] bl2[7] bl2_n[7] bl1[8] bl1_n[8] bl2[8] bl2_n[8] bl1[9] bl1_n[9] bl2[9] bl2_n[9] bl1[10] bl1_n[10] bl2[10] bl2_n[10] bl1[11] bl1_n[11] bl2[11] bl2_n[11] bl1[12] bl1_n[12] bl2[12] bl2_n[12] bl1[13] bl1_n[13] bl2[13] bl2_n[13] bl1[14] bl1_n[14] bl2[14] bl2_n[14] bl1[15] bl1_n[15] bl2[15] bl2_n[15] bl1[16] bl1_n[16] bl2[16] bl2_n[16] bl1[17] bl1_n[17] bl2[17] bl2_n[17] bl1[18] bl1_n[18] bl2[18] bl2_n[18] bl1[19] bl1_n[19] bl2[19] bl2_n[19] bl1[20] bl1_n[20] bl2[20] bl2_n[20] bl1[21] bl1_n[21] bl2[21] bl2_n[21] bl1[22] bl1_n[22] bl2[22] bl2_n[22] bl1[23] bl1_n[23] bl2[23] bl2_n[23] bl1[24] bl1_n[24] bl2[24] bl2_n[24] bl1[25] bl1_n[25] bl2[25] bl2_n[25] bl1[26] bl1_n[26] bl2[26] bl2_n[26] bl1[27] bl1_n[27] bl2[27] bl2_n[27] bl1[28] bl1_n[28] bl2[28] bl2_n[28] bl1[29] bl1_n[29] bl2[29] bl2_n[29] bl1[30] bl1_n[30] bl2[30] bl2_n[30] bl1[31] bl1_n[31] bl2[31] bl2_n[31]
Xinst0x0 vss vdd wl1[0] wl2[0] wl1[1] wl2[1] wl1[2] wl2[2] wl1[3] wl2[3] wl1[4] wl2[4] wl1[5] wl2[5] wl1[6] wl2[6] wl1[7] wl2[7] wl1[8] wl2[8] wl1[9] wl2[9] wl1[10] wl2[10] wl1[11] wl2[11] wl1[12] wl2[12] wl1[13] wl2[13] wl1[14] wl2[14] wl1[15] wl2[15] wl1[16] wl2[16] wl1[17] wl2[17] wl1[18] wl2[18] wl1[19] wl2[19] wl1[20] wl2[20] wl1[21] wl2[21] wl1[22] wl2[22] wl1[23] wl2[23] wl1[24] wl2[24] wl1[25] wl2[25] wl1[26] wl2[26] wl1[27] wl2[27] wl1[28] wl2[28] wl1[29] wl2[29] wl1[30] wl2[30] wl1[31] wl2[31] bl1[0] bl1_n[0] bl2[0] bl2_n[0] bl1[1] bl1_n[1] bl2[1] bl2_n[1] bl1[2] bl1_n[2] bl2[2] bl2_n[2] bl1[3] bl1_n[3] bl2[3] bl2_n[3] bl1[4] bl1_n[4] bl2[4] bl2_n[4] bl1[5] bl1_n[5] bl2[5] bl2_n[5] bl1[6] bl1_n[6] bl2[6] bl2_n[6] bl1[7] bl1_n[7] bl2[7] bl2_n[7] bl1[8] bl1_n[8] bl2[8] bl2_n[8] bl1[9] bl1_n[9] bl2[9] bl2_n[9] bl1[10] bl1_n[10] bl2[10] bl2_n[10] bl1[11] bl1_n[11] bl2[11] bl2_n[11] bl1[12] bl1_n[12] bl2[12] bl2_n[12] bl1[13] bl1_n[13] bl2[13] bl2_n[13] bl1[14] bl1_n[14] bl2[14] bl2_n[14] bl1[15] bl1_n[15] bl2[15] bl2_n[15] bl1[16] bl1_n[16] bl2[16] bl2_n[16] bl1[17] bl1_n[17] bl2[17] bl2_n[17] bl1[18] bl1_n[18] bl2[18] bl2_n[18] bl1[19] bl1_n[19] bl2[19] bl2_n[19] bl1[20] bl1_n[20] bl2[20] bl2_n[20] bl1[21] bl1_n[21] bl2[21] bl2_n[21] bl1[22] bl1_n[22] bl2[22] bl2_n[22] bl1[23] bl1_n[23] bl2[23] bl2_n[23] bl1[24] bl1_n[24] bl2[24] bl2_n[24] bl1[25] bl1_n[25] bl2[25] bl2_n[25] bl1[26] bl1_n[26] bl2[26] bl2_n[26] bl1[27] bl1_n[27] bl2[27] bl2_n[27] bl1[28] bl1_n[28] bl2[28] bl2_n[28] bl1[29] bl1_n[29] bl2[29] bl2_n[29] bl1[30] bl1_n[30] bl2[30] bl2_n[30] bl1[31] bl1_n[31] bl2[31] bl2_n[31] DP8TArray_32X32
Xinst1x0 vss vdd wl1[32] wl2[32] wl1[33] wl2[33] wl1[34] wl2[34] wl1[35] wl2[35] wl1[36] wl2[36] wl1[37] wl2[37] wl1[38] wl2[38] wl1[39] wl2[39] wl1[40] wl2[40] wl1[41] wl2[41] wl1[42] wl2[42] wl1[43] wl2[43] wl1[44] wl2[44] wl1[45] wl2[45] wl1[46] wl2[46] wl1[47] wl2[47] wl1[48] wl2[48] wl1[49] wl2[49] wl1[50] wl2[50] wl1[51] wl2[51] wl1[52] wl2[52] wl1[53] wl2[53] wl1[54] wl2[54] wl1[55] wl2[55] wl1[56] wl2[56] wl1[57] wl2[57] wl1[58] wl2[58] wl1[59] wl2[59] wl1[60] wl2[60] wl1[61] wl2[61] wl1[62] wl2[62] wl1[63] wl2[63] bl1[0] bl1_n[0] bl2[0] bl2_n[0] bl1[1] bl1_n[1] bl2[1] bl2_n[1] bl1[2] bl1_n[2] bl2[2] bl2_n[2] bl1[3] bl1_n[3] bl2[3] bl2_n[3] bl1[4] bl1_n[4] bl2[4] bl2_n[4] bl1[5] bl1_n[5] bl2[5] bl2_n[5] bl1[6] bl1_n[6] bl2[6] bl2_n[6] bl1[7] bl1_n[7] bl2[7] bl2_n[7] bl1[8] bl1_n[8] bl2[8] bl2_n[8] bl1[9] bl1_n[9] bl2[9] bl2_n[9] bl1[10] bl1_n[10] bl2[10] bl2_n[10] bl1[11] bl1_n[11] bl2[11] bl2_n[11] bl1[12] bl1_n[12] bl2[12] bl2_n[12] bl1[13] bl1_n[13] bl2[13] bl2_n[13] bl1[14] bl1_n[14] bl2[14] bl2_n[14] bl1[15] bl1_n[15] bl2[15] bl2_n[15] bl1[16] bl1_n[16] bl2[16] bl2_n[16] bl1[17] bl1_n[17] bl2[17] bl2_n[17] bl1[18] bl1_n[18] bl2[18] bl2_n[18] bl1[19] bl1_n[19] bl2[19] bl2_n[19] bl1[20] bl1_n[20] bl2[20] bl2_n[20] bl1[21] bl1_n[21] bl2[21] bl2_n[21] bl1[22] bl1_n[22] bl2[22] bl2_n[22] bl1[23] bl1_n[23] bl2[23] bl2_n[23] bl1[24] bl1_n[24] bl2[24] bl2_n[24] bl1[25] bl1_n[25] bl2[25] bl2_n[25] bl1[26] bl1_n[26] bl2[26] bl2_n[26] bl1[27] bl1_n[27] bl2[27] bl2_n[27] bl1[28] bl1_n[28] bl2[28] bl2_n[28] bl1[29] bl1_n[29] bl2[29] bl2_n[29] bl1[30] bl1_n[30] bl2[30] bl2_n[30] bl1[31] bl1_n[31] bl2[31] bl2_n[31] DP8TArray_32X32
Xbcrow vss vdd bl1[0] bl1_n[0] bl2[0] bl2_n[0] bl1[1] bl1_n[1] bl2[1] bl2_n[1] bl1[2] bl1_n[2] bl2[2] bl2_n[2] bl1[3] bl1_n[3] bl2[3] bl2_n[3] bl1[4] bl1_n[4] bl2[4] bl2_n[4] bl1[5] bl1_n[5] bl2[5] bl2_n[5] bl1[6] bl1_n[6] bl2[6] bl2_n[6] bl1[7] bl1_n[7] bl2[7] bl2_n[7] bl1[8] bl1_n[8] bl2[8] bl2_n[8] bl1[9] bl1_n[9] bl2[9] bl2_n[9] bl1[10] bl1_n[10] bl2[10] bl2_n[10] bl1[11] bl1_n[11] bl2[11] bl2_n[11] bl1[12] bl1_n[12] bl2[12] bl2_n[12] bl1[13] bl1_n[13] bl2[13] bl2_n[13] bl1[14] bl1_n[14] bl2[14] bl2_n[14] bl1[15] bl1_n[15] bl2[15] bl2_n[15] bl1[16] bl1_n[16] bl2[16] bl2_n[16] bl1[17] bl1_n[17] bl2[17] bl2_n[17] bl1[18] bl1_n[18] bl2[18] bl2_n[18] bl1[19] bl1_n[19] bl2[19] bl2_n[19] bl1[20] bl1_n[20] bl2[20] bl2_n[20] bl1[21] bl1_n[21] bl2[21] bl2_n[21] bl1[22] bl1_n[22] bl2[22] bl2_n[22] bl1[23] bl1_n[23] bl2[23] bl2_n[23] bl1[24] bl1_n[24] bl2[24] bl2_n[24] bl1[25] bl1_n[25] bl2[25] bl2_n[25] bl1[26] bl1_n[26] bl2[26] bl2_n[26] bl1[27] bl1_n[27] bl2[27] bl2_n[27] bl1[28] bl1_n[28] bl2[28] bl2_n[28] bl1[29] bl1_n[29] bl2[29] bl2_n[29] bl1[30] bl1_n[30] bl2[30] bl2_n[30] bl1[31] bl1_n[31] bl2[31] bl2_n[31] DP8TBulkConnRow_32
.ends DP8TArray_64X32

.subckt DP8TArray_128X32BC vss vdd wl1[0] wl2[0] wl1[1] wl2[1] wl1[2] wl2[2] wl1[3] wl2[3] wl1[4] wl2[4] wl1[5] wl2[5] wl1[6] wl2[6] wl1[7] wl2[7] wl1[8] wl2[8] wl1[9] wl2[9] wl1[10] wl2[10] wl1[11] wl2[11] wl1[12] wl2[12] wl1[13] wl2[13] wl1[14] wl2[14] wl1[15] wl2[15] wl1[16] wl2[16] wl1[17] wl2[17] wl1[18] wl2[18] wl1[19] wl2[19] wl1[20] wl2[20] wl1[21] wl2[21] wl1[22] wl2[22] wl1[23] wl2[23] wl1[24] wl2[24] wl1[25] wl2[25] wl1[26] wl2[26] wl1[27] wl2[27] wl1[28] wl2[28] wl1[29] wl2[29] wl1[30] wl2[30] wl1[31] wl2[31] wl1[32] wl2[32] wl1[33] wl2[33] wl1[34] wl2[34] wl1[35] wl2[35] wl1[36] wl2[36] wl1[37] wl2[37] wl1[38] wl2[38] wl1[39] wl2[39] wl1[40] wl2[40] wl1[41] wl2[41] wl1[42] wl2[42] wl1[43] wl2[43] wl1[44] wl2[44] wl1[45] wl2[45] wl1[46] wl2[46] wl1[47] wl2[47] wl1[48] wl2[48] wl1[49] wl2[49] wl1[50] wl2[50] wl1[51] wl2[51] wl1[52] wl2[52] wl1[53] wl2[53] wl1[54] wl2[54] wl1[55] wl2[55] wl1[56] wl2[56] wl1[57] wl2[57] wl1[58] wl2[58] wl1[59] wl2[59] wl1[60] wl2[60] wl1[61] wl2[61] wl1[62] wl2[62] wl1[63] wl2[63] wl1[64] wl2[64] wl1[65] wl2[65] wl1[66] wl2[66] wl1[67] wl2[67] wl1[68] wl2[68] wl1[69] wl2[69] wl1[70] wl2[70] wl1[71] wl2[71] wl1[72] wl2[72] wl1[73] wl2[73] wl1[74] wl2[74] wl1[75] wl2[75] wl1[76] wl2[76] wl1[77] wl2[77] wl1[78] wl2[78] wl1[79] wl2[79] wl1[80] wl2[80] wl1[81] wl2[81] wl1[82] wl2[82] wl1[83] wl2[83] wl1[84] wl2[84] wl1[85] wl2[85] wl1[86] wl2[86] wl1[87] wl2[87] wl1[88] wl2[88] wl1[89] wl2[89] wl1[90] wl2[90] wl1[91] wl2[91] wl1[92] wl2[92] wl1[93] wl2[93] wl1[94] wl2[94] wl1[95] wl2[95] wl1[96] wl2[96] wl1[97] wl2[97] wl1[98] wl2[98] wl1[99] wl2[99] wl1[100] wl2[100] wl1[101] wl2[101] wl1[102] wl2[102] wl1[103] wl2[103] wl1[104] wl2[104] wl1[105] wl2[105] wl1[106] wl2[106] wl1[107] wl2[107] wl1[108] wl2[108] wl1[109] wl2[109] wl1[110] wl2[110] wl1[111] wl2[111] wl1[112] wl2[112] wl1[113] wl2[113] wl1[114] wl2[114] wl1[115] wl2[115] wl1[116] wl2[116] wl1[117] wl2[117] wl1[118] wl2[118] wl1[119] wl2[119] wl1[120] wl2[120] wl1[121] wl2[121] wl1[122] wl2[122] wl1[123] wl2[123] wl1[124] wl2[124] wl1[125] wl2[125] wl1[126] wl2[126] wl1[127] wl2[127] bl1[0] bl1_n[0] bl2[0] bl2_n[0] bl1[1] bl1_n[1] bl2[1] bl2_n[1] bl1[2] bl1_n[2] bl2[2] bl2_n[2] bl1[3] bl1_n[3] bl2[3] bl2_n[3] bl1[4] bl1_n[4] bl2[4] bl2_n[4] bl1[5] bl1_n[5] bl2[5] bl2_n[5] bl1[6] bl1_n[6] bl2[6] bl2_n[6] bl1[7] bl1_n[7] bl2[7] bl2_n[7] bl1[8] bl1_n[8] bl2[8] bl2_n[8] bl1[9] bl1_n[9] bl2[9] bl2_n[9] bl1[10] bl1_n[10] bl2[10] bl2_n[10] bl1[11] bl1_n[11] bl2[11] bl2_n[11] bl1[12] bl1_n[12] bl2[12] bl2_n[12] bl1[13] bl1_n[13] bl2[13] bl2_n[13] bl1[14] bl1_n[14] bl2[14] bl2_n[14] bl1[15] bl1_n[15] bl2[15] bl2_n[15] bl1[16] bl1_n[16] bl2[16] bl2_n[16] bl1[17] bl1_n[17] bl2[17] bl2_n[17] bl1[18] bl1_n[18] bl2[18] bl2_n[18] bl1[19] bl1_n[19] bl2[19] bl2_n[19] bl1[20] bl1_n[20] bl2[20] bl2_n[20] bl1[21] bl1_n[21] bl2[21] bl2_n[21] bl1[22] bl1_n[22] bl2[22] bl2_n[22] bl1[23] bl1_n[23] bl2[23] bl2_n[23] bl1[24] bl1_n[24] bl2[24] bl2_n[24] bl1[25] bl1_n[25] bl2[25] bl2_n[25] bl1[26] bl1_n[26] bl2[26] bl2_n[26] bl1[27] bl1_n[27] bl2[27] bl2_n[27] bl1[28] bl1_n[28] bl2[28] bl2_n[28] bl1[29] bl1_n[29] bl2[29] bl2_n[29] bl1[30] bl1_n[30] bl2[30] bl2_n[30] bl1[31] bl1_n[31] bl2[31] bl2_n[31]
Xinst0x0 vss vdd wl1[0] wl2[0] wl1[1] wl2[1] wl1[2] wl2[2] wl1[3] wl2[3] wl1[4] wl2[4] wl1[5] wl2[5] wl1[6] wl2[6] wl1[7] wl2[7] wl1[8] wl2[8] wl1[9] wl2[9] wl1[10] wl2[10] wl1[11] wl2[11] wl1[12] wl2[12] wl1[13] wl2[13] wl1[14] wl2[14] wl1[15] wl2[15] wl1[16] wl2[16] wl1[17] wl2[17] wl1[18] wl2[18] wl1[19] wl2[19] wl1[20] wl2[20] wl1[21] wl2[21] wl1[22] wl2[22] wl1[23] wl2[23] wl1[24] wl2[24] wl1[25] wl2[25] wl1[26] wl2[26] wl1[27] wl2[27] wl1[28] wl2[28] wl1[29] wl2[29] wl1[30] wl2[30] wl1[31] wl2[31] wl1[32] wl2[32] wl1[33] wl2[33] wl1[34] wl2[34] wl1[35] wl2[35] wl1[36] wl2[36] wl1[37] wl2[37] wl1[38] wl2[38] wl1[39] wl2[39] wl1[40] wl2[40] wl1[41] wl2[41] wl1[42] wl2[42] wl1[43] wl2[43] wl1[44] wl2[44] wl1[45] wl2[45] wl1[46] wl2[46] wl1[47] wl2[47] wl1[48] wl2[48] wl1[49] wl2[49] wl1[50] wl2[50] wl1[51] wl2[51] wl1[52] wl2[52] wl1[53] wl2[53] wl1[54] wl2[54] wl1[55] wl2[55] wl1[56] wl2[56] wl1[57] wl2[57] wl1[58] wl2[58] wl1[59] wl2[59] wl1[60] wl2[60] wl1[61] wl2[61] wl1[62] wl2[62] wl1[63] wl2[63] bl1[0] bl1_n[0] bl2[0] bl2_n[0] bl1[1] bl1_n[1] bl2[1] bl2_n[1] bl1[2] bl1_n[2] bl2[2] bl2_n[2] bl1[3] bl1_n[3] bl2[3] bl2_n[3] bl1[4] bl1_n[4] bl2[4] bl2_n[4] bl1[5] bl1_n[5] bl2[5] bl2_n[5] bl1[6] bl1_n[6] bl2[6] bl2_n[6] bl1[7] bl1_n[7] bl2[7] bl2_n[7] bl1[8] bl1_n[8] bl2[8] bl2_n[8] bl1[9] bl1_n[9] bl2[9] bl2_n[9] bl1[10] bl1_n[10] bl2[10] bl2_n[10] bl1[11] bl1_n[11] bl2[11] bl2_n[11] bl1[12] bl1_n[12] bl2[12] bl2_n[12] bl1[13] bl1_n[13] bl2[13] bl2_n[13] bl1[14] bl1_n[14] bl2[14] bl2_n[14] bl1[15] bl1_n[15] bl2[15] bl2_n[15] bl1[16] bl1_n[16] bl2[16] bl2_n[16] bl1[17] bl1_n[17] bl2[17] bl2_n[17] bl1[18] bl1_n[18] bl2[18] bl2_n[18] bl1[19] bl1_n[19] bl2[19] bl2_n[19] bl1[20] bl1_n[20] bl2[20] bl2_n[20] bl1[21] bl1_n[21] bl2[21] bl2_n[21] bl1[22] bl1_n[22] bl2[22] bl2_n[22] bl1[23] bl1_n[23] bl2[23] bl2_n[23] bl1[24] bl1_n[24] bl2[24] bl2_n[24] bl1[25] bl1_n[25] bl2[25] bl2_n[25] bl1[26] bl1_n[26] bl2[26] bl2_n[26] bl1[27] bl1_n[27] bl2[27] bl2_n[27] bl1[28] bl1_n[28] bl2[28] bl2_n[28] bl1[29] bl1_n[29] bl2[29] bl2_n[29] bl1[30] bl1_n[30] bl2[30] bl2_n[30] bl1[31] bl1_n[31] bl2[31] bl2_n[31] DP8TArray_64X32
Xinst1x0 vss vdd wl1[64] wl2[64] wl1[65] wl2[65] wl1[66] wl2[66] wl1[67] wl2[67] wl1[68] wl2[68] wl1[69] wl2[69] wl1[70] wl2[70] wl1[71] wl2[71] wl1[72] wl2[72] wl1[73] wl2[73] wl1[74] wl2[74] wl1[75] wl2[75] wl1[76] wl2[76] wl1[77] wl2[77] wl1[78] wl2[78] wl1[79] wl2[79] wl1[80] wl2[80] wl1[81] wl2[81] wl1[82] wl2[82] wl1[83] wl2[83] wl1[84] wl2[84] wl1[85] wl2[85] wl1[86] wl2[86] wl1[87] wl2[87] wl1[88] wl2[88] wl1[89] wl2[89] wl1[90] wl2[90] wl1[91] wl2[91] wl1[92] wl2[92] wl1[93] wl2[93] wl1[94] wl2[94] wl1[95] wl2[95] wl1[96] wl2[96] wl1[97] wl2[97] wl1[98] wl2[98] wl1[99] wl2[99] wl1[100] wl2[100] wl1[101] wl2[101] wl1[102] wl2[102] wl1[103] wl2[103] wl1[104] wl2[104] wl1[105] wl2[105] wl1[106] wl2[106] wl1[107] wl2[107] wl1[108] wl2[108] wl1[109] wl2[109] wl1[110] wl2[110] wl1[111] wl2[111] wl1[112] wl2[112] wl1[113] wl2[113] wl1[114] wl2[114] wl1[115] wl2[115] wl1[116] wl2[116] wl1[117] wl2[117] wl1[118] wl2[118] wl1[119] wl2[119] wl1[120] wl2[120] wl1[121] wl2[121] wl1[122] wl2[122] wl1[123] wl2[123] wl1[124] wl2[124] wl1[125] wl2[125] wl1[126] wl2[126] wl1[127] wl2[127] bl1[0] bl1_n[0] bl2[0] bl2_n[0] bl1[1] bl1_n[1] bl2[1] bl2_n[1] bl1[2] bl1_n[2] bl2[2] bl2_n[2] bl1[3] bl1_n[3] bl2[3] bl2_n[3] bl1[4] bl1_n[4] bl2[4] bl2_n[4] bl1[5] bl1_n[5] bl2[5] bl2_n[5] bl1[6] bl1_n[6] bl2[6] bl2_n[6] bl1[7] bl1_n[7] bl2[7] bl2_n[7] bl1[8] bl1_n[8] bl2[8] bl2_n[8] bl1[9] bl1_n[9] bl2[9] bl2_n[9] bl1[10] bl1_n[10] bl2[10] bl2_n[10] bl1[11] bl1_n[11] bl2[11] bl2_n[11] bl1[12] bl1_n[12] bl2[12] bl2_n[12] bl1[13] bl1_n[13] bl2[13] bl2_n[13] bl1[14] bl1_n[14] bl2[14] bl2_n[14] bl1[15] bl1_n[15] bl2[15] bl2_n[15] bl1[16] bl1_n[16] bl2[16] bl2_n[16] bl1[17] bl1_n[17] bl2[17] bl2_n[17] bl1[18] bl1_n[18] bl2[18] bl2_n[18] bl1[19] bl1_n[19] bl2[19] bl2_n[19] bl1[20] bl1_n[20] bl2[20] bl2_n[20] bl1[21] bl1_n[21] bl2[21] bl2_n[21] bl1[22] bl1_n[22] bl2[22] bl2_n[22] bl1[23] bl1_n[23] bl2[23] bl2_n[23] bl1[24] bl1_n[24] bl2[24] bl2_n[24] bl1[25] bl1_n[25] bl2[25] bl2_n[25] bl1[26] bl1_n[26] bl2[26] bl2_n[26] bl1[27] bl1_n[27] bl2[27] bl2_n[27] bl1[28] bl1_n[28] bl2[28] bl2_n[28] bl1[29] bl1_n[29] bl2[29] bl2_n[29] bl1[30] bl1_n[30] bl2[30] bl2_n[30] bl1[31] bl1_n[31] bl2[31] bl2_n[31] DP8TArray_64X32
Xbcrow vss vdd bl1[0] bl1_n[0] bl2[0] bl2_n[0] bl1[1] bl1_n[1] bl2[1] bl2_n[1] bl1[2] bl1_n[2] bl2[2] bl2_n[2] bl1[3] bl1_n[3] bl2[3] bl2_n[3] bl1[4] bl1_n[4] bl2[4] bl2_n[4] bl1[5] bl1_n[5] bl2[5] bl2_n[5] bl1[6] bl1_n[6] bl2[6] bl2_n[6] bl1[7] bl1_n[7] bl2[7] bl2_n[7] bl1[8] bl1_n[8] bl2[8] bl2_n[8] bl1[9] bl1_n[9] bl2[9] bl2_n[9] bl1[10] bl1_n[10] bl2[10] bl2_n[10] bl1[11] bl1_n[11] bl2[11] bl2_n[11] bl1[12] bl1_n[12] bl2[12] bl2_n[12] bl1[13] bl1_n[13] bl2[13] bl2_n[13] bl1[14] bl1_n[14] bl2[14] bl2_n[14] bl1[15] bl1_n[15] bl2[15] bl2_n[15] bl1[16] bl1_n[16] bl2[16] bl2_n[16] bl1[17] bl1_n[17] bl2[17] bl2_n[17] bl1[18] bl1_n[18] bl2[18] bl2_n[18] bl1[19] bl1_n[19] bl2[19] bl2_n[19] bl1[20] bl1_n[20] bl2[20] bl2_n[20] bl1[21] bl1_n[21] bl2[21] bl2_n[21] bl1[22] bl1_n[22] bl2[22] bl2_n[22] bl1[23] bl1_n[23] bl2[23] bl2_n[23] bl1[24] bl1_n[24] bl2[24] bl2_n[24] bl1[25] bl1_n[25] bl2[25] bl2_n[25] bl1[26] bl1_n[26] bl2[26] bl2_n[26] bl1[27] bl1_n[27] bl2[27] bl2_n[27] bl1[28] bl1_n[28] bl2[28] bl2_n[28] bl1[29] bl1_n[29] bl2[29] bl2_n[29] bl1[30] bl1_n[30] bl2[30] bl2_n[30] bl1[31] bl1_n[31] bl2[31] bl2_n[31] DP8TBulkConnRow_32
Xbottombcrow vss vdd bl1[0] bl1_n[0] bl2[0] bl2_n[0] bl1[1] bl1_n[1] bl2[1] bl2_n[1] bl1[2] bl1_n[2] bl2[2] bl2_n[2] bl1[3] bl1_n[3] bl2[3] bl2_n[3] bl1[4] bl1_n[4] bl2[4] bl2_n[4] bl1[5] bl1_n[5] bl2[5] bl2_n[5] bl1[6] bl1_n[6] bl2[6] bl2_n[6] bl1[7] bl1_n[7] bl2[7] bl2_n[7] bl1[8] bl1_n[8] bl2[8] bl2_n[8] bl1[9] bl1_n[9] bl2[9] bl2_n[9] bl1[10] bl1_n[10] bl2[10] bl2_n[10] bl1[11] bl1_n[11] bl2[11] bl2_n[11] bl1[12] bl1_n[12] bl2[12] bl2_n[12] bl1[13] bl1_n[13] bl2[13] bl2_n[13] bl1[14] bl1_n[14] bl2[14] bl2_n[14] bl1[15] bl1_n[15] bl2[15] bl2_n[15] bl1[16] bl1_n[16] bl2[16] bl2_n[16] bl1[17] bl1_n[17] bl2[17] bl2_n[17] bl1[18] bl1_n[18] bl2[18] bl2_n[18] bl1[19] bl1_n[19] bl2[19] bl2_n[19] bl1[20] bl1_n[20] bl2[20] bl2_n[20] bl1[21] bl1_n[21] bl2[21] bl2_n[21] bl1[22] bl1_n[22] bl2[22] bl2_n[22] bl1[23] bl1_n[23] bl2[23] bl2_n[23] bl1[24] bl1_n[24] bl2[24] bl2_n[24] bl1[25] bl1_n[25] bl2[25] bl2_n[25] bl1[26] bl1_n[26] bl2[26] bl2_n[26] bl1[27] bl1_n[27] bl2[27] bl2_n[27] bl1[28] bl1_n[28] bl2[28] bl2_n[28] bl1[29] bl1_n[29] bl2[29] bl2_n[29] bl1[30] bl1_n[30] bl2[30] bl2_n[30] bl1[31] bl1_n[31] bl2[31] bl2_n[31] DP8TBulkConnRow_32
Xtopbcrow vss vdd bl1[0] bl1_n[0] bl2[0] bl2_n[0] bl1[1] bl1_n[1] bl2[1] bl2_n[1] bl1[2] bl1_n[2] bl2[2] bl2_n[2] bl1[3] bl1_n[3] bl2[3] bl2_n[3] bl1[4] bl1_n[4] bl2[4] bl2_n[4] bl1[5] bl1_n[5] bl2[5] bl2_n[5] bl1[6] bl1_n[6] bl2[6] bl2_n[6] bl1[7] bl1_n[7] bl2[7] bl2_n[7] bl1[8] bl1_n[8] bl2[8] bl2_n[8] bl1[9] bl1_n[9] bl2[9] bl2_n[9] bl1[10] bl1_n[10] bl2[10] bl2_n[10] bl1[11] bl1_n[11] bl2[11] bl2_n[11] bl1[12] bl1_n[12] bl2[12] bl2_n[12] bl1[13] bl1_n[13] bl2[13] bl2_n[13] bl1[14] bl1_n[14] bl2[14] bl2_n[14] bl1[15] bl1_n[15] bl2[15] bl2_n[15] bl1[16] bl1_n[16] bl2[16] bl2_n[16] bl1[17] bl1_n[17] bl2[17] bl2_n[17] bl1[18] bl1_n[18] bl2[18] bl2_n[18] bl1[19] bl1_n[19] bl2[19] bl2_n[19] bl1[20] bl1_n[20] bl2[20] bl2_n[20] bl1[21] bl1_n[21] bl2[21] bl2_n[21] bl1[22] bl1_n[22] bl2[22] bl2_n[22] bl1[23] bl1_n[23] bl2[23] bl2_n[23] bl1[24] bl1_n[24] bl2[24] bl2_n[24] bl1[25] bl1_n[25] bl2[25] bl2_n[25] bl1[26] bl1_n[26] bl2[26] bl2_n[26] bl1[27] bl1_n[27] bl2[27] bl2_n[27] bl1[28] bl1_n[28] bl2[28] bl2_n[28] bl1[29] bl1_n[29] bl2[29] bl2_n[29] bl1[30] bl1_n[30] bl2[30] bl2_n[30] bl1[31] bl1_n[31] bl2[31] bl2_n[31] DP8TBulkConnRow_32
.ends DP8TArray_128X32BC

.subckt DP8TPrecharge_bl1 vdd bl bl_n precharge_n
Xpc1 vdd precharge_n bl vdd sg13_lv_pmos l=1.3e-07 w=5e-07
Xpc2 bl precharge_n bl_n vdd sg13_lv_pmos l=1.3e-07 w=5e-07
Xpc3 bl_n precharge_n vdd vdd sg13_lv_pmos l=1.3e-07 w=5e-07
.ends DP8TPrecharge_bl1

.subckt DP8TColMux_4C_bl1 bl[0] bl_n[0] mux[0] bl[1] bl_n[1] mux[1] bl[2] bl_n[2] mux[2] bl[3] bl_n[3] mux[3] vss muxbl muxbl_n
Xpgbl0 muxbl mux[0] bl[0] vss sg13_lv_nmos l=1.3e-07 w=3.5e-06
Xpgbln0 bl_n[0] mux[0] muxbl_n vss sg13_lv_nmos l=1.3e-07 w=3.5e-06
Xpgbl1 bl[1] mux[1] muxbl vss sg13_lv_nmos l=1.3e-07 w=3.5e-06
Xpgbln1 muxbl_n mux[1] bl_n[1] vss sg13_lv_nmos l=1.3e-07 w=3.5e-06
Xpgbl2 muxbl mux[2] bl[2] vss sg13_lv_nmos l=1.3e-07 w=3.5e-06
Xpgbln2 bl_n[2] mux[2] muxbl_n vss sg13_lv_nmos l=1.3e-07 w=3.5e-06
Xpgbl3 bl[3] mux[3] muxbl vss sg13_lv_nmos l=1.3e-07 w=3.5e-06
Xpgbln3 muxbl_n mux[3] bl_n[3] vss sg13_lv_nmos l=1.3e-07 w=3.5e-06
.ends DP8TColMux_4C_bl1

.subckt DP8TReadWrite_4M vss vdd d q bl bl_n clk we_n
Xsenseamp vdd vss bl_n bl q noconn nsnrlatch_x1
Xd_ff vdd vss d clk d_l dff_x1
Xd_inv vdd vss d_l d_n inv_x0
Xnora vdd vss bl_pd_g d_l we_n nor2_x0
Xnorb vdd vss bln_pd_g d_n we_n nor2_x0
Xbl_pd bl bl_pd_g vss vss sg13_lv_nmos l=1.3e-07 w=1.9e-06
Xbln_pd vss bln_pd_g bl_n vss sg13_lv_nmos l=1.3e-07 w=1.9e-06
.ends DP8TReadWrite_4M

.subckt DP8TClockWE vss vdd clkup clkdown we we_en we_n
Xclkbuf vdd vss clkup clkdown buf_x2
Xweff vdd vss we clkdown we_l dff_x1
Xwenand vdd vss we_n we_l we_en nand2_x0
.ends DP8TClockWE

.subckt DP8TColumnPeriphery_8B4M_bl1 vss vdd clk precharge_n we we_en q[0] d[0] bl[0] bl_n[0] bl[1] bl_n[1] bl[2] bl_n[2] bl[3] bl_n[3] q[1] d[1] bl[4] bl_n[4] bl[5] bl_n[5] bl[6] bl_n[6] bl[7] bl_n[7] q[2] d[2] bl[8] bl_n[8] bl[9] bl_n[9] bl[10] bl_n[10] bl[11] bl_n[11] q[3] d[3] bl[12] bl_n[12] bl[13] bl_n[13] bl[14] bl_n[14] bl[15] bl_n[15] q[4] d[4] bl[16] bl_n[16] bl[17] bl_n[17] bl[18] bl_n[18] bl[19] bl_n[19] q[5] d[5] bl[20] bl_n[20] bl[21] bl_n[21] bl[22] bl_n[22] bl[23] bl_n[23] q[6] d[6] bl[24] bl_n[24] bl[25] bl_n[25] bl[26] bl_n[26] bl[27] bl_n[27] q[7] d[7] bl[28] bl_n[28] bl[29] bl_n[29] bl[30] bl_n[30] bl[31] bl_n[31] mux[0] mux[1] mux[2] mux[3]
Xprecharge[0] vdd bl[0] bl_n[0] precharge_n DP8TPrecharge_bl1
Xprecharge[1] vdd bl[1] bl_n[1] precharge_n DP8TPrecharge_bl1
Xprecharge[2] vdd bl[2] bl_n[2] precharge_n DP8TPrecharge_bl1
Xprecharge[3] vdd bl[3] bl_n[3] precharge_n DP8TPrecharge_bl1
Xprecharge[4] vdd bl[4] bl_n[4] precharge_n DP8TPrecharge_bl1
Xprecharge[5] vdd bl[5] bl_n[5] precharge_n DP8TPrecharge_bl1
Xprecharge[6] vdd bl[6] bl_n[6] precharge_n DP8TPrecharge_bl1
Xprecharge[7] vdd bl[7] bl_n[7] precharge_n DP8TPrecharge_bl1
Xprecharge[8] vdd bl[8] bl_n[8] precharge_n DP8TPrecharge_bl1
Xprecharge[9] vdd bl[9] bl_n[9] precharge_n DP8TPrecharge_bl1
Xprecharge[10] vdd bl[10] bl_n[10] precharge_n DP8TPrecharge_bl1
Xprecharge[11] vdd bl[11] bl_n[11] precharge_n DP8TPrecharge_bl1
Xprecharge[12] vdd bl[12] bl_n[12] precharge_n DP8TPrecharge_bl1
Xprecharge[13] vdd bl[13] bl_n[13] precharge_n DP8TPrecharge_bl1
Xprecharge[14] vdd bl[14] bl_n[14] precharge_n DP8TPrecharge_bl1
Xprecharge[15] vdd bl[15] bl_n[15] precharge_n DP8TPrecharge_bl1
Xprecharge[16] vdd bl[16] bl_n[16] precharge_n DP8TPrecharge_bl1
Xprecharge[17] vdd bl[17] bl_n[17] precharge_n DP8TPrecharge_bl1
Xprecharge[18] vdd bl[18] bl_n[18] precharge_n DP8TPrecharge_bl1
Xprecharge[19] vdd bl[19] bl_n[19] precharge_n DP8TPrecharge_bl1
Xprecharge[20] vdd bl[20] bl_n[20] precharge_n DP8TPrecharge_bl1
Xprecharge[21] vdd bl[21] bl_n[21] precharge_n DP8TPrecharge_bl1
Xprecharge[22] vdd bl[22] bl_n[22] precharge_n DP8TPrecharge_bl1
Xprecharge[23] vdd bl[23] bl_n[23] precharge_n DP8TPrecharge_bl1
Xprecharge[24] vdd bl[24] bl_n[24] precharge_n DP8TPrecharge_bl1
Xprecharge[25] vdd bl[25] bl_n[25] precharge_n DP8TPrecharge_bl1
Xprecharge[26] vdd bl[26] bl_n[26] precharge_n DP8TPrecharge_bl1
Xprecharge[27] vdd bl[27] bl_n[27] precharge_n DP8TPrecharge_bl1
Xprecharge[28] vdd bl[28] bl_n[28] precharge_n DP8TPrecharge_bl1
Xprecharge[29] vdd bl[29] bl_n[29] precharge_n DP8TPrecharge_bl1
Xprecharge[30] vdd bl[30] bl_n[30] precharge_n DP8TPrecharge_bl1
Xprecharge[31] vdd bl[31] bl_n[31] precharge_n DP8TPrecharge_bl1
Xcolmux[0] bl[0] bl_n[0] mux[0] bl[1] bl_n[1] mux[1] bl[2] bl_n[2] mux[2] bl[3] bl_n[3] mux[3] vss muxbl[0] muxbl_n[0] DP8TColMux_4C_bl1
Xcolmux[1] bl[4] bl_n[4] mux[0] bl[5] bl_n[5] mux[1] bl[6] bl_n[6] mux[2] bl[7] bl_n[7] mux[3] vss muxbl[1] muxbl_n[1] DP8TColMux_4C_bl1
Xcolmux[2] bl[8] bl_n[8] mux[0] bl[9] bl_n[9] mux[1] bl[10] bl_n[10] mux[2] bl[11] bl_n[11] mux[3] vss muxbl[2] muxbl_n[2] DP8TColMux_4C_bl1
Xcolmux[3] bl[12] bl_n[12] mux[0] bl[13] bl_n[13] mux[1] bl[14] bl_n[14] mux[2] bl[15] bl_n[15] mux[3] vss muxbl[3] muxbl_n[3] DP8TColMux_4C_bl1
Xcolmux[4] bl[16] bl_n[16] mux[0] bl[17] bl_n[17] mux[1] bl[18] bl_n[18] mux[2] bl[19] bl_n[19] mux[3] vss muxbl[4] muxbl_n[4] DP8TColMux_4C_bl1
Xcolmux[5] bl[20] bl_n[20] mux[0] bl[21] bl_n[21] mux[1] bl[22] bl_n[22] mux[2] bl[23] bl_n[23] mux[3] vss muxbl[5] muxbl_n[5] DP8TColMux_4C_bl1
Xcolmux[6] bl[24] bl_n[24] mux[0] bl[25] bl_n[25] mux[1] bl[26] bl_n[26] mux[2] bl[27] bl_n[27] mux[3] vss muxbl[6] muxbl_n[6] DP8TColMux_4C_bl1
Xcolmux[7] bl[28] bl_n[28] mux[0] bl[29] bl_n[29] mux[1] bl[30] bl_n[30] mux[2] bl[31] bl_n[31] mux[3] vss muxbl[7] muxbl_n[7] DP8TColMux_4C_bl1
Xrw[0] vss vdd d[0] q[0] muxbl[0] muxbl_n[0] intclk we_n DP8TReadWrite_4M
Xrw[1] vss vdd d[1] q[1] muxbl[1] muxbl_n[1] intclk we_n DP8TReadWrite_4M
Xrw[2] vss vdd d[2] q[2] muxbl[2] muxbl_n[2] intclk we_n DP8TReadWrite_4M
Xrw[3] vss vdd d[3] q[3] muxbl[3] muxbl_n[3] intclk we_n DP8TReadWrite_4M
Xrw[4] vss vdd d[4] q[4] muxbl[4] muxbl_n[4] intclk we_n DP8TReadWrite_4M
Xrw[5] vss vdd d[5] q[5] muxbl[5] muxbl_n[5] intclk we_n DP8TReadWrite_4M
Xrw[6] vss vdd d[6] q[6] muxbl[6] muxbl_n[6] intclk we_n DP8TReadWrite_4M
Xrw[7] vss vdd d[7] q[7] muxbl[7] muxbl_n[7] intclk we_n DP8TReadWrite_4M
Xclkwe vss vdd clk intclk we we_en we_n DP8TClockWE
.ends DP8TColumnPeriphery_8B4M_bl1

.subckt DP8TPrecharge_bl2 vdd bl bl_n precharge_n
Xpc1 vdd precharge_n bl vdd sg13_lv_pmos l=1.3e-07 w=5e-07
Xpc2 bl precharge_n bl_n vdd sg13_lv_pmos l=1.3e-07 w=5e-07
Xpc3 bl_n precharge_n vdd vdd sg13_lv_pmos l=1.3e-07 w=5e-07
.ends DP8TPrecharge_bl2

.subckt DP8TColMux_4C_bl2 bl[0] bl_n[0] mux[0] bl[1] bl_n[1] mux[1] bl[2] bl_n[2] mux[2] bl[3] bl_n[3] mux[3] vss muxbl muxbl_n
Xpgbl0 muxbl mux[0] bl[0] vss sg13_lv_nmos l=1.3e-07 w=3.5e-06
Xpgbln0 bl_n[0] mux[0] muxbl_n vss sg13_lv_nmos l=1.3e-07 w=3.5e-06
Xpgbl1 bl[1] mux[1] muxbl vss sg13_lv_nmos l=1.3e-07 w=3.5e-06
Xpgbln1 muxbl_n mux[1] bl_n[1] vss sg13_lv_nmos l=1.3e-07 w=3.5e-06
Xpgbl2 muxbl mux[2] bl[2] vss sg13_lv_nmos l=1.3e-07 w=3.5e-06
Xpgbln2 bl_n[2] mux[2] muxbl_n vss sg13_lv_nmos l=1.3e-07 w=3.5e-06
Xpgbl3 bl[3] mux[3] muxbl vss sg13_lv_nmos l=1.3e-07 w=3.5e-06
Xpgbln3 muxbl_n mux[3] bl_n[3] vss sg13_lv_nmos l=1.3e-07 w=3.5e-06
.ends DP8TColMux_4C_bl2

.subckt DP8TColumnPeriphery_8B4M_bl2 vss vdd clk precharge_n we we_en q[0] d[0] bl[0] bl_n[0] bl[1] bl_n[1] bl[2] bl_n[2] bl[3] bl_n[3] q[1] d[1] bl[4] bl_n[4] bl[5] bl_n[5] bl[6] bl_n[6] bl[7] bl_n[7] q[2] d[2] bl[8] bl_n[8] bl[9] bl_n[9] bl[10] bl_n[10] bl[11] bl_n[11] q[3] d[3] bl[12] bl_n[12] bl[13] bl_n[13] bl[14] bl_n[14] bl[15] bl_n[15] q[4] d[4] bl[16] bl_n[16] bl[17] bl_n[17] bl[18] bl_n[18] bl[19] bl_n[19] q[5] d[5] bl[20] bl_n[20] bl[21] bl_n[21] bl[22] bl_n[22] bl[23] bl_n[23] q[6] d[6] bl[24] bl_n[24] bl[25] bl_n[25] bl[26] bl_n[26] bl[27] bl_n[27] q[7] d[7] bl[28] bl_n[28] bl[29] bl_n[29] bl[30] bl_n[30] bl[31] bl_n[31] mux[0] mux[1] mux[2] mux[3]
Xprecharge[0] vdd bl[0] bl_n[0] precharge_n DP8TPrecharge_bl2
Xprecharge[1] vdd bl[1] bl_n[1] precharge_n DP8TPrecharge_bl2
Xprecharge[2] vdd bl[2] bl_n[2] precharge_n DP8TPrecharge_bl2
Xprecharge[3] vdd bl[3] bl_n[3] precharge_n DP8TPrecharge_bl2
Xprecharge[4] vdd bl[4] bl_n[4] precharge_n DP8TPrecharge_bl2
Xprecharge[5] vdd bl[5] bl_n[5] precharge_n DP8TPrecharge_bl2
Xprecharge[6] vdd bl[6] bl_n[6] precharge_n DP8TPrecharge_bl2
Xprecharge[7] vdd bl[7] bl_n[7] precharge_n DP8TPrecharge_bl2
Xprecharge[8] vdd bl[8] bl_n[8] precharge_n DP8TPrecharge_bl2
Xprecharge[9] vdd bl[9] bl_n[9] precharge_n DP8TPrecharge_bl2
Xprecharge[10] vdd bl[10] bl_n[10] precharge_n DP8TPrecharge_bl2
Xprecharge[11] vdd bl[11] bl_n[11] precharge_n DP8TPrecharge_bl2
Xprecharge[12] vdd bl[12] bl_n[12] precharge_n DP8TPrecharge_bl2
Xprecharge[13] vdd bl[13] bl_n[13] precharge_n DP8TPrecharge_bl2
Xprecharge[14] vdd bl[14] bl_n[14] precharge_n DP8TPrecharge_bl2
Xprecharge[15] vdd bl[15] bl_n[15] precharge_n DP8TPrecharge_bl2
Xprecharge[16] vdd bl[16] bl_n[16] precharge_n DP8TPrecharge_bl2
Xprecharge[17] vdd bl[17] bl_n[17] precharge_n DP8TPrecharge_bl2
Xprecharge[18] vdd bl[18] bl_n[18] precharge_n DP8TPrecharge_bl2
Xprecharge[19] vdd bl[19] bl_n[19] precharge_n DP8TPrecharge_bl2
Xprecharge[20] vdd bl[20] bl_n[20] precharge_n DP8TPrecharge_bl2
Xprecharge[21] vdd bl[21] bl_n[21] precharge_n DP8TPrecharge_bl2
Xprecharge[22] vdd bl[22] bl_n[22] precharge_n DP8TPrecharge_bl2
Xprecharge[23] vdd bl[23] bl_n[23] precharge_n DP8TPrecharge_bl2
Xprecharge[24] vdd bl[24] bl_n[24] precharge_n DP8TPrecharge_bl2
Xprecharge[25] vdd bl[25] bl_n[25] precharge_n DP8TPrecharge_bl2
Xprecharge[26] vdd bl[26] bl_n[26] precharge_n DP8TPrecharge_bl2
Xprecharge[27] vdd bl[27] bl_n[27] precharge_n DP8TPrecharge_bl2
Xprecharge[28] vdd bl[28] bl_n[28] precharge_n DP8TPrecharge_bl2
Xprecharge[29] vdd bl[29] bl_n[29] precharge_n DP8TPrecharge_bl2
Xprecharge[30] vdd bl[30] bl_n[30] precharge_n DP8TPrecharge_bl2
Xprecharge[31] vdd bl[31] bl_n[31] precharge_n DP8TPrecharge_bl2
Xcolmux[0] bl[0] bl_n[0] mux[0] bl[1] bl_n[1] mux[1] bl[2] bl_n[2] mux[2] bl[3] bl_n[3] mux[3] vss muxbl[0] muxbl_n[0] DP8TColMux_4C_bl2
Xcolmux[1] bl[4] bl_n[4] mux[0] bl[5] bl_n[5] mux[1] bl[6] bl_n[6] mux[2] bl[7] bl_n[7] mux[3] vss muxbl[1] muxbl_n[1] DP8TColMux_4C_bl2
Xcolmux[2] bl[8] bl_n[8] mux[0] bl[9] bl_n[9] mux[1] bl[10] bl_n[10] mux[2] bl[11] bl_n[11] mux[3] vss muxbl[2] muxbl_n[2] DP8TColMux_4C_bl2
Xcolmux[3] bl[12] bl_n[12] mux[0] bl[13] bl_n[13] mux[1] bl[14] bl_n[14] mux[2] bl[15] bl_n[15] mux[3] vss muxbl[3] muxbl_n[3] DP8TColMux_4C_bl2
Xcolmux[4] bl[16] bl_n[16] mux[0] bl[17] bl_n[17] mux[1] bl[18] bl_n[18] mux[2] bl[19] bl_n[19] mux[3] vss muxbl[4] muxbl_n[4] DP8TColMux_4C_bl2
Xcolmux[5] bl[20] bl_n[20] mux[0] bl[21] bl_n[21] mux[1] bl[22] bl_n[22] mux[2] bl[23] bl_n[23] mux[3] vss muxbl[5] muxbl_n[5] DP8TColMux_4C_bl2
Xcolmux[6] bl[24] bl_n[24] mux[0] bl[25] bl_n[25] mux[1] bl[26] bl_n[26] mux[2] bl[27] bl_n[27] mux[3] vss muxbl[6] muxbl_n[6] DP8TColMux_4C_bl2
Xcolmux[7] bl[28] bl_n[28] mux[0] bl[29] bl_n[29] mux[1] bl[30] bl_n[30] mux[2] bl[31] bl_n[31] mux[3] vss muxbl[7] muxbl_n[7] DP8TColMux_4C_bl2
Xrw[0] vss vdd d[0] q[0] muxbl[0] muxbl_n[0] intclk we_n DP8TReadWrite_4M
Xrw[1] vss vdd d[1] q[1] muxbl[1] muxbl_n[1] intclk we_n DP8TReadWrite_4M
Xrw[2] vss vdd d[2] q[2] muxbl[2] muxbl_n[2] intclk we_n DP8TReadWrite_4M
Xrw[3] vss vdd d[3] q[3] muxbl[3] muxbl_n[3] intclk we_n DP8TReadWrite_4M
Xrw[4] vss vdd d[4] q[4] muxbl[4] muxbl_n[4] intclk we_n DP8TReadWrite_4M
Xrw[5] vss vdd d[5] q[5] muxbl[5] muxbl_n[5] intclk we_n DP8TReadWrite_4M
Xrw[6] vss vdd d[6] q[6] muxbl[6] muxbl_n[6] intclk we_n DP8TReadWrite_4M
Xrw[7] vss vdd d[7] q[7] muxbl[7] muxbl_n[7] intclk we_n DP8TReadWrite_4M
Xclkwe vss vdd clk intclk we we_en we_n DP8TClockWE
.ends DP8TColumnPeriphery_8B4M_bl2

.subckt DP8TColumn_128R8B4M vss vdd wl1[0] wl2[0] wl1[1] wl2[1] wl1[2] wl2[2] wl1[3] wl2[3] wl1[4] wl2[4] wl1[5] wl2[5] wl1[6] wl2[6] wl1[7] wl2[7] wl1[8] wl2[8] wl1[9] wl2[9] wl1[10] wl2[10] wl1[11] wl2[11] wl1[12] wl2[12] wl1[13] wl2[13] wl1[14] wl2[14] wl1[15] wl2[15] wl1[16] wl2[16] wl1[17] wl2[17] wl1[18] wl2[18] wl1[19] wl2[19] wl1[20] wl2[20] wl1[21] wl2[21] wl1[22] wl2[22] wl1[23] wl2[23] wl1[24] wl2[24] wl1[25] wl2[25] wl1[26] wl2[26] wl1[27] wl2[27] wl1[28] wl2[28] wl1[29] wl2[29] wl1[30] wl2[30] wl1[31] wl2[31] wl1[32] wl2[32] wl1[33] wl2[33] wl1[34] wl2[34] wl1[35] wl2[35] wl1[36] wl2[36] wl1[37] wl2[37] wl1[38] wl2[38] wl1[39] wl2[39] wl1[40] wl2[40] wl1[41] wl2[41] wl1[42] wl2[42] wl1[43] wl2[43] wl1[44] wl2[44] wl1[45] wl2[45] wl1[46] wl2[46] wl1[47] wl2[47] wl1[48] wl2[48] wl1[49] wl2[49] wl1[50] wl2[50] wl1[51] wl2[51] wl1[52] wl2[52] wl1[53] wl2[53] wl1[54] wl2[54] wl1[55] wl2[55] wl1[56] wl2[56] wl1[57] wl2[57] wl1[58] wl2[58] wl1[59] wl2[59] wl1[60] wl2[60] wl1[61] wl2[61] wl1[62] wl2[62] wl1[63] wl2[63] wl1[64] wl2[64] wl1[65] wl2[65] wl1[66] wl2[66] wl1[67] wl2[67] wl1[68] wl2[68] wl1[69] wl2[69] wl1[70] wl2[70] wl1[71] wl2[71] wl1[72] wl2[72] wl1[73] wl2[73] wl1[74] wl2[74] wl1[75] wl2[75] wl1[76] wl2[76] wl1[77] wl2[77] wl1[78] wl2[78] wl1[79] wl2[79] wl1[80] wl2[80] wl1[81] wl2[81] wl1[82] wl2[82] wl1[83] wl2[83] wl1[84] wl2[84] wl1[85] wl2[85] wl1[86] wl2[86] wl1[87] wl2[87] wl1[88] wl2[88] wl1[89] wl2[89] wl1[90] wl2[90] wl1[91] wl2[91] wl1[92] wl2[92] wl1[93] wl2[93] wl1[94] wl2[94] wl1[95] wl2[95] wl1[96] wl2[96] wl1[97] wl2[97] wl1[98] wl2[98] wl1[99] wl2[99] wl1[100] wl2[100] wl1[101] wl2[101] wl1[102] wl2[102] wl1[103] wl2[103] wl1[104] wl2[104] wl1[105] wl2[105] wl1[106] wl2[106] wl1[107] wl2[107] wl1[108] wl2[108] wl1[109] wl2[109] wl1[110] wl2[110] wl1[111] wl2[111] wl1[112] wl2[112] wl1[113] wl2[113] wl1[114] wl2[114] wl1[115] wl2[115] wl1[116] wl2[116] wl1[117] wl2[117] wl1[118] wl2[118] wl1[119] wl2[119] wl1[120] wl2[120] wl1[121] wl2[121] wl1[122] wl2[122] wl1[123] wl2[123] wl1[124] wl2[124] wl1[125] wl2[125] wl1[126] wl2[126] wl1[127] wl2[127] q1[0] q2[7] d1[0] d2[7] q1[1] q2[6] d1[1] d2[6] q1[2] q2[5] d1[2] d2[5] q1[3] q2[4] d1[3] d2[4] q1[4] q2[3] d1[4] d2[3] q1[5] q2[2] d1[5] d2[2] q1[6] q2[1] d1[6] d2[1] q1[7] q2[0] d1[7] d2[0] we1 clk1 we_en1 precharge1_n we2 clk2 we_en2 precharge2_n mux1[0] mux2[0] mux1[1] mux2[1] mux1[2] mux2[2] mux1[3] mux2[3]
Xarray vss vdd wl1[0] wl2[0] wl1[1] wl2[1] wl1[2] wl2[2] wl1[3] wl2[3] wl1[4] wl2[4] wl1[5] wl2[5] wl1[6] wl2[6] wl1[7] wl2[7] wl1[8] wl2[8] wl1[9] wl2[9] wl1[10] wl2[10] wl1[11] wl2[11] wl1[12] wl2[12] wl1[13] wl2[13] wl1[14] wl2[14] wl1[15] wl2[15] wl1[16] wl2[16] wl1[17] wl2[17] wl1[18] wl2[18] wl1[19] wl2[19] wl1[20] wl2[20] wl1[21] wl2[21] wl1[22] wl2[22] wl1[23] wl2[23] wl1[24] wl2[24] wl1[25] wl2[25] wl1[26] wl2[26] wl1[27] wl2[27] wl1[28] wl2[28] wl1[29] wl2[29] wl1[30] wl2[30] wl1[31] wl2[31] wl1[32] wl2[32] wl1[33] wl2[33] wl1[34] wl2[34] wl1[35] wl2[35] wl1[36] wl2[36] wl1[37] wl2[37] wl1[38] wl2[38] wl1[39] wl2[39] wl1[40] wl2[40] wl1[41] wl2[41] wl1[42] wl2[42] wl1[43] wl2[43] wl1[44] wl2[44] wl1[45] wl2[45] wl1[46] wl2[46] wl1[47] wl2[47] wl1[48] wl2[48] wl1[49] wl2[49] wl1[50] wl2[50] wl1[51] wl2[51] wl1[52] wl2[52] wl1[53] wl2[53] wl1[54] wl2[54] wl1[55] wl2[55] wl1[56] wl2[56] wl1[57] wl2[57] wl1[58] wl2[58] wl1[59] wl2[59] wl1[60] wl2[60] wl1[61] wl2[61] wl1[62] wl2[62] wl1[63] wl2[63] wl1[64] wl2[64] wl1[65] wl2[65] wl1[66] wl2[66] wl1[67] wl2[67] wl1[68] wl2[68] wl1[69] wl2[69] wl1[70] wl2[70] wl1[71] wl2[71] wl1[72] wl2[72] wl1[73] wl2[73] wl1[74] wl2[74] wl1[75] wl2[75] wl1[76] wl2[76] wl1[77] wl2[77] wl1[78] wl2[78] wl1[79] wl2[79] wl1[80] wl2[80] wl1[81] wl2[81] wl1[82] wl2[82] wl1[83] wl2[83] wl1[84] wl2[84] wl1[85] wl2[85] wl1[86] wl2[86] wl1[87] wl2[87] wl1[88] wl2[88] wl1[89] wl2[89] wl1[90] wl2[90] wl1[91] wl2[91] wl1[92] wl2[92] wl1[93] wl2[93] wl1[94] wl2[94] wl1[95] wl2[95] wl1[96] wl2[96] wl1[97] wl2[97] wl1[98] wl2[98] wl1[99] wl2[99] wl1[100] wl2[100] wl1[101] wl2[101] wl1[102] wl2[102] wl1[103] wl2[103] wl1[104] wl2[104] wl1[105] wl2[105] wl1[106] wl2[106] wl1[107] wl2[107] wl1[108] wl2[108] wl1[109] wl2[109] wl1[110] wl2[110] wl1[111] wl2[111] wl1[112] wl2[112] wl1[113] wl2[113] wl1[114] wl2[114] wl1[115] wl2[115] wl1[116] wl2[116] wl1[117] wl2[117] wl1[118] wl2[118] wl1[119] wl2[119] wl1[120] wl2[120] wl1[121] wl2[121] wl1[122] wl2[122] wl1[123] wl2[123] wl1[124] wl2[124] wl1[125] wl2[125] wl1[126] wl2[126] wl1[127] wl2[127] bl1[0] bl1_n[0] bl2[0] bl2_n[0] bl1[1] bl1_n[1] bl2[1] bl2_n[1] bl1[2] bl1_n[2] bl2[2] bl2_n[2] bl1[3] bl1_n[3] bl2[3] bl2_n[3] bl1[4] bl1_n[4] bl2[4] bl2_n[4] bl1[5] bl1_n[5] bl2[5] bl2_n[5] bl1[6] bl1_n[6] bl2[6] bl2_n[6] bl1[7] bl1_n[7] bl2[7] bl2_n[7] bl1[8] bl1_n[8] bl2[8] bl2_n[8] bl1[9] bl1_n[9] bl2[9] bl2_n[9] bl1[10] bl1_n[10] bl2[10] bl2_n[10] bl1[11] bl1_n[11] bl2[11] bl2_n[11] bl1[12] bl1_n[12] bl2[12] bl2_n[12] bl1[13] bl1_n[13] bl2[13] bl2_n[13] bl1[14] bl1_n[14] bl2[14] bl2_n[14] bl1[15] bl1_n[15] bl2[15] bl2_n[15] bl1[16] bl1_n[16] bl2[16] bl2_n[16] bl1[17] bl1_n[17] bl2[17] bl2_n[17] bl1[18] bl1_n[18] bl2[18] bl2_n[18] bl1[19] bl1_n[19] bl2[19] bl2_n[19] bl1[20] bl1_n[20] bl2[20] bl2_n[20] bl1[21] bl1_n[21] bl2[21] bl2_n[21] bl1[22] bl1_n[22] bl2[22] bl2_n[22] bl1[23] bl1_n[23] bl2[23] bl2_n[23] bl1[24] bl1_n[24] bl2[24] bl2_n[24] bl1[25] bl1_n[25] bl2[25] bl2_n[25] bl1[26] bl1_n[26] bl2[26] bl2_n[26] bl1[27] bl1_n[27] bl2[27] bl2_n[27] bl1[28] bl1_n[28] bl2[28] bl2_n[28] bl1[29] bl1_n[29] bl2[29] bl2_n[29] bl1[30] bl1_n[30] bl2[30] bl2_n[30] bl1[31] bl1_n[31] bl2[31] bl2_n[31] DP8TArray_128X32BC
Xperiph1 vss vdd clk1 precharge1_n we1 we_en1 q1[0] d1[0] bl1[0] bl1_n[0] bl1[1] bl1_n[1] bl1[2] bl1_n[2] bl1[3] bl1_n[3] q1[1] d1[1] bl1[4] bl1_n[4] bl1[5] bl1_n[5] bl1[6] bl1_n[6] bl1[7] bl1_n[7] q1[2] d1[2] bl1[8] bl1_n[8] bl1[9] bl1_n[9] bl1[10] bl1_n[10] bl1[11] bl1_n[11] q1[3] d1[3] bl1[12] bl1_n[12] bl1[13] bl1_n[13] bl1[14] bl1_n[14] bl1[15] bl1_n[15] q1[4] d1[4] bl1[16] bl1_n[16] bl1[17] bl1_n[17] bl1[18] bl1_n[18] bl1[19] bl1_n[19] q1[5] d1[5] bl1[20] bl1_n[20] bl1[21] bl1_n[21] bl1[22] bl1_n[22] bl1[23] bl1_n[23] q1[6] d1[6] bl1[24] bl1_n[24] bl1[25] bl1_n[25] bl1[26] bl1_n[26] bl1[27] bl1_n[27] q1[7] d1[7] bl1[28] bl1_n[28] bl1[29] bl1_n[29] bl1[30] bl1_n[30] bl1[31] bl1_n[31] mux1[0] mux1[1] mux1[2] mux1[3] DP8TColumnPeriphery_8B4M_bl1
Xperiph2 vss vdd clk2 precharge2_n we2 we_en2 q2[7] d2[7] bl2[31] bl2_n[31] bl2[30] bl2_n[30] bl2[29] bl2_n[29] bl2[28] bl2_n[28] q2[6] d2[6] bl2[27] bl2_n[27] bl2[26] bl2_n[26] bl2[25] bl2_n[25] bl2[24] bl2_n[24] q2[5] d2[5] bl2[23] bl2_n[23] bl2[22] bl2_n[22] bl2[21] bl2_n[21] bl2[20] bl2_n[20] q2[4] d2[4] bl2[19] bl2_n[19] bl2[18] bl2_n[18] bl2[17] bl2_n[17] bl2[16] bl2_n[16] q2[3] d2[3] bl2[15] bl2_n[15] bl2[14] bl2_n[14] bl2[13] bl2_n[13] bl2[12] bl2_n[12] q2[2] d2[2] bl2[11] bl2_n[11] bl2[10] bl2_n[10] bl2[9] bl2_n[9] bl2[8] bl2_n[8] q2[1] d2[1] bl2[7] bl2_n[7] bl2[6] bl2_n[6] bl2[5] bl2_n[5] bl2[4] bl2_n[4] q2[0] d2[0] bl2[3] bl2_n[3] bl2[2] bl2_n[2] bl2[1] bl2_n[1] bl2[0] bl2_n[0] mux2[0] mux2[1] mux2[2] mux2[3] DP8TColumnPeriphery_8B4M_bl2
.ends DP8TColumn_128R8B4M

.subckt DP8TColumnBlock_128R32B4M4W vss vdd clk1 clk2 precharge1_n precharge2_n we_en1 we_en2 wl1[0] wl1[1] wl1[2] wl1[3] wl1[4] wl1[5] wl1[6] wl1[7] wl1[8] wl1[9] wl1[10] wl1[11] wl1[12] wl1[13] wl1[14] wl1[15] wl1[16] wl1[17] wl1[18] wl1[19] wl1[20] wl1[21] wl1[22] wl1[23] wl1[24] wl1[25] wl1[26] wl1[27] wl1[28] wl1[29] wl1[30] wl1[31] wl1[32] wl1[33] wl1[34] wl1[35] wl1[36] wl1[37] wl1[38] wl1[39] wl1[40] wl1[41] wl1[42] wl1[43] wl1[44] wl1[45] wl1[46] wl1[47] wl1[48] wl1[49] wl1[50] wl1[51] wl1[52] wl1[53] wl1[54] wl1[55] wl1[56] wl1[57] wl1[58] wl1[59] wl1[60] wl1[61] wl1[62] wl1[63] wl1[64] wl1[65] wl1[66] wl1[67] wl1[68] wl1[69] wl1[70] wl1[71] wl1[72] wl1[73] wl1[74] wl1[75] wl1[76] wl1[77] wl1[78] wl1[79] wl1[80] wl1[81] wl1[82] wl1[83] wl1[84] wl1[85] wl1[86] wl1[87] wl1[88] wl1[89] wl1[90] wl1[91] wl1[92] wl1[93] wl1[94] wl1[95] wl1[96] wl1[97] wl1[98] wl1[99] wl1[100] wl1[101] wl1[102] wl1[103] wl1[104] wl1[105] wl1[106] wl1[107] wl1[108] wl1[109] wl1[110] wl1[111] wl1[112] wl1[113] wl1[114] wl1[115] wl1[116] wl1[117] wl1[118] wl1[119] wl1[120] wl1[121] wl1[122] wl1[123] wl1[124] wl1[125] wl1[126] wl1[127] wl2[0] wl2[1] wl2[2] wl2[3] wl2[4] wl2[5] wl2[6] wl2[7] wl2[8] wl2[9] wl2[10] wl2[11] wl2[12] wl2[13] wl2[14] wl2[15] wl2[16] wl2[17] wl2[18] wl2[19] wl2[20] wl2[21] wl2[22] wl2[23] wl2[24] wl2[25] wl2[26] wl2[27] wl2[28] wl2[29] wl2[30] wl2[31] wl2[32] wl2[33] wl2[34] wl2[35] wl2[36] wl2[37] wl2[38] wl2[39] wl2[40] wl2[41] wl2[42] wl2[43] wl2[44] wl2[45] wl2[46] wl2[47] wl2[48] wl2[49] wl2[50] wl2[51] wl2[52] wl2[53] wl2[54] wl2[55] wl2[56] wl2[57] wl2[58] wl2[59] wl2[60] wl2[61] wl2[62] wl2[63] wl2[64] wl2[65] wl2[66] wl2[67] wl2[68] wl2[69] wl2[70] wl2[71] wl2[72] wl2[73] wl2[74] wl2[75] wl2[76] wl2[77] wl2[78] wl2[79] wl2[80] wl2[81] wl2[82] wl2[83] wl2[84] wl2[85] wl2[86] wl2[87] wl2[88] wl2[89] wl2[90] wl2[91] wl2[92] wl2[93] wl2[94] wl2[95] wl2[96] wl2[97] wl2[98] wl2[99] wl2[100] wl2[101] wl2[102] wl2[103] wl2[104] wl2[105] wl2[106] wl2[107] wl2[108] wl2[109] wl2[110] wl2[111] wl2[112] wl2[113] wl2[114] wl2[115] wl2[116] wl2[117] wl2[118] wl2[119] wl2[120] wl2[121] wl2[122] wl2[123] wl2[124] wl2[125] wl2[126] wl2[127] mux1[0] mux1[1] mux1[2] mux1[3] mux2[0] mux2[1] mux2[2] mux2[3] we1[0] we2[0] q1[0] q2[0] d1[0] d2[0] q1[1] q2[1] d1[1] d2[1] q1[2] q2[2] d1[2] d2[2] q1[3] q2[3] d1[3] d2[3] q1[4] q2[4] d1[4] d2[4] q1[5] q2[5] d1[5] d2[5] q1[6] q2[6] d1[6] d2[6] q1[7] q2[7] d1[7] d2[7] we1[1] we2[1] q1[8] q2[8] d1[8] d2[8] q1[9] q2[9] d1[9] d2[9] q1[10] q2[10] d1[10] d2[10] q1[11] q2[11] d1[11] d2[11] q1[12] q2[12] d1[12] d2[12] q1[13] q2[13] d1[13] d2[13] q1[14] q2[14] d1[14] d2[14] q1[15] q2[15] d1[15] d2[15] we1[2] we2[2] q1[16] q2[16] d1[16] d2[16] q1[17] q2[17] d1[17] d2[17] q1[18] q2[18] d1[18] d2[18] q1[19] q2[19] d1[19] d2[19] q1[20] q2[20] d1[20] d2[20] q1[21] q2[21] d1[21] d2[21] q1[22] q2[22] d1[22] d2[22] q1[23] q2[23] d1[23] d2[23] we1[3] we2[3] q1[24] q2[24] d1[24] d2[24] q1[25] q2[25] d1[25] d2[25] q1[26] q2[26] d1[26] d2[26] q1[27] q2[27] d1[27] d2[27] q1[28] q2[28] d1[28] d2[28] q1[29] q2[29] d1[29] d2[29] q1[30] q2[30] d1[30] d2[30] q1[31] q2[31] d1[31] d2[31]
Xcolumn[0] vss vdd wl1[0] wl2[0] wl1[1] wl2[1] wl1[2] wl2[2] wl1[3] wl2[3] wl1[4] wl2[4] wl1[5] wl2[5] wl1[6] wl2[6] wl1[7] wl2[7] wl1[8] wl2[8] wl1[9] wl2[9] wl1[10] wl2[10] wl1[11] wl2[11] wl1[12] wl2[12] wl1[13] wl2[13] wl1[14] wl2[14] wl1[15] wl2[15] wl1[16] wl2[16] wl1[17] wl2[17] wl1[18] wl2[18] wl1[19] wl2[19] wl1[20] wl2[20] wl1[21] wl2[21] wl1[22] wl2[22] wl1[23] wl2[23] wl1[24] wl2[24] wl1[25] wl2[25] wl1[26] wl2[26] wl1[27] wl2[27] wl1[28] wl2[28] wl1[29] wl2[29] wl1[30] wl2[30] wl1[31] wl2[31] wl1[32] wl2[32] wl1[33] wl2[33] wl1[34] wl2[34] wl1[35] wl2[35] wl1[36] wl2[36] wl1[37] wl2[37] wl1[38] wl2[38] wl1[39] wl2[39] wl1[40] wl2[40] wl1[41] wl2[41] wl1[42] wl2[42] wl1[43] wl2[43] wl1[44] wl2[44] wl1[45] wl2[45] wl1[46] wl2[46] wl1[47] wl2[47] wl1[48] wl2[48] wl1[49] wl2[49] wl1[50] wl2[50] wl1[51] wl2[51] wl1[52] wl2[52] wl1[53] wl2[53] wl1[54] wl2[54] wl1[55] wl2[55] wl1[56] wl2[56] wl1[57] wl2[57] wl1[58] wl2[58] wl1[59] wl2[59] wl1[60] wl2[60] wl1[61] wl2[61] wl1[62] wl2[62] wl1[63] wl2[63] wl1[64] wl2[64] wl1[65] wl2[65] wl1[66] wl2[66] wl1[67] wl2[67] wl1[68] wl2[68] wl1[69] wl2[69] wl1[70] wl2[70] wl1[71] wl2[71] wl1[72] wl2[72] wl1[73] wl2[73] wl1[74] wl2[74] wl1[75] wl2[75] wl1[76] wl2[76] wl1[77] wl2[77] wl1[78] wl2[78] wl1[79] wl2[79] wl1[80] wl2[80] wl1[81] wl2[81] wl1[82] wl2[82] wl1[83] wl2[83] wl1[84] wl2[84] wl1[85] wl2[85] wl1[86] wl2[86] wl1[87] wl2[87] wl1[88] wl2[88] wl1[89] wl2[89] wl1[90] wl2[90] wl1[91] wl2[91] wl1[92] wl2[92] wl1[93] wl2[93] wl1[94] wl2[94] wl1[95] wl2[95] wl1[96] wl2[96] wl1[97] wl2[97] wl1[98] wl2[98] wl1[99] wl2[99] wl1[100] wl2[100] wl1[101] wl2[101] wl1[102] wl2[102] wl1[103] wl2[103] wl1[104] wl2[104] wl1[105] wl2[105] wl1[106] wl2[106] wl1[107] wl2[107] wl1[108] wl2[108] wl1[109] wl2[109] wl1[110] wl2[110] wl1[111] wl2[111] wl1[112] wl2[112] wl1[113] wl2[113] wl1[114] wl2[114] wl1[115] wl2[115] wl1[116] wl2[116] wl1[117] wl2[117] wl1[118] wl2[118] wl1[119] wl2[119] wl1[120] wl2[120] wl1[121] wl2[121] wl1[122] wl2[122] wl1[123] wl2[123] wl1[124] wl2[124] wl1[125] wl2[125] wl1[126] wl2[126] wl1[127] wl2[127] q1[0] q2[7] d1[0] d2[7] q1[1] q2[6] d1[1] d2[6] q1[2] q2[5] d1[2] d2[5] q1[3] q2[4] d1[3] d2[4] q1[4] q2[3] d1[4] d2[3] q1[5] q2[2] d1[5] d2[2] q1[6] q2[1] d1[6] d2[1] q1[7] q2[0] d1[7] d2[0] we1[0] clk1 we_en1 precharge1_n we2[0] clk2 we_en2 precharge2_n mux1[0] mux2[0] mux1[1] mux2[1] mux1[2] mux2[2] mux1[3] mux2[3] DP8TColumn_128R8B4M
Xcolumn[1] vss vdd wl1[0] wl2[0] wl1[1] wl2[1] wl1[2] wl2[2] wl1[3] wl2[3] wl1[4] wl2[4] wl1[5] wl2[5] wl1[6] wl2[6] wl1[7] wl2[7] wl1[8] wl2[8] wl1[9] wl2[9] wl1[10] wl2[10] wl1[11] wl2[11] wl1[12] wl2[12] wl1[13] wl2[13] wl1[14] wl2[14] wl1[15] wl2[15] wl1[16] wl2[16] wl1[17] wl2[17] wl1[18] wl2[18] wl1[19] wl2[19] wl1[20] wl2[20] wl1[21] wl2[21] wl1[22] wl2[22] wl1[23] wl2[23] wl1[24] wl2[24] wl1[25] wl2[25] wl1[26] wl2[26] wl1[27] wl2[27] wl1[28] wl2[28] wl1[29] wl2[29] wl1[30] wl2[30] wl1[31] wl2[31] wl1[32] wl2[32] wl1[33] wl2[33] wl1[34] wl2[34] wl1[35] wl2[35] wl1[36] wl2[36] wl1[37] wl2[37] wl1[38] wl2[38] wl1[39] wl2[39] wl1[40] wl2[40] wl1[41] wl2[41] wl1[42] wl2[42] wl1[43] wl2[43] wl1[44] wl2[44] wl1[45] wl2[45] wl1[46] wl2[46] wl1[47] wl2[47] wl1[48] wl2[48] wl1[49] wl2[49] wl1[50] wl2[50] wl1[51] wl2[51] wl1[52] wl2[52] wl1[53] wl2[53] wl1[54] wl2[54] wl1[55] wl2[55] wl1[56] wl2[56] wl1[57] wl2[57] wl1[58] wl2[58] wl1[59] wl2[59] wl1[60] wl2[60] wl1[61] wl2[61] wl1[62] wl2[62] wl1[63] wl2[63] wl1[64] wl2[64] wl1[65] wl2[65] wl1[66] wl2[66] wl1[67] wl2[67] wl1[68] wl2[68] wl1[69] wl2[69] wl1[70] wl2[70] wl1[71] wl2[71] wl1[72] wl2[72] wl1[73] wl2[73] wl1[74] wl2[74] wl1[75] wl2[75] wl1[76] wl2[76] wl1[77] wl2[77] wl1[78] wl2[78] wl1[79] wl2[79] wl1[80] wl2[80] wl1[81] wl2[81] wl1[82] wl2[82] wl1[83] wl2[83] wl1[84] wl2[84] wl1[85] wl2[85] wl1[86] wl2[86] wl1[87] wl2[87] wl1[88] wl2[88] wl1[89] wl2[89] wl1[90] wl2[90] wl1[91] wl2[91] wl1[92] wl2[92] wl1[93] wl2[93] wl1[94] wl2[94] wl1[95] wl2[95] wl1[96] wl2[96] wl1[97] wl2[97] wl1[98] wl2[98] wl1[99] wl2[99] wl1[100] wl2[100] wl1[101] wl2[101] wl1[102] wl2[102] wl1[103] wl2[103] wl1[104] wl2[104] wl1[105] wl2[105] wl1[106] wl2[106] wl1[107] wl2[107] wl1[108] wl2[108] wl1[109] wl2[109] wl1[110] wl2[110] wl1[111] wl2[111] wl1[112] wl2[112] wl1[113] wl2[113] wl1[114] wl2[114] wl1[115] wl2[115] wl1[116] wl2[116] wl1[117] wl2[117] wl1[118] wl2[118] wl1[119] wl2[119] wl1[120] wl2[120] wl1[121] wl2[121] wl1[122] wl2[122] wl1[123] wl2[123] wl1[124] wl2[124] wl1[125] wl2[125] wl1[126] wl2[126] wl1[127] wl2[127] q1[8] q2[15] d1[8] d2[15] q1[9] q2[14] d1[9] d2[14] q1[10] q2[13] d1[10] d2[13] q1[11] q2[12] d1[11] d2[12] q1[12] q2[11] d1[12] d2[11] q1[13] q2[10] d1[13] d2[10] q1[14] q2[9] d1[14] d2[9] q1[15] q2[8] d1[15] d2[8] we1[1] clk1 we_en1 precharge1_n we2[1] clk2 we_en2 precharge2_n mux1[0] mux2[0] mux1[1] mux2[1] mux1[2] mux2[2] mux1[3] mux2[3] DP8TColumn_128R8B4M
Xcolumn[2] vss vdd wl1[0] wl2[0] wl1[1] wl2[1] wl1[2] wl2[2] wl1[3] wl2[3] wl1[4] wl2[4] wl1[5] wl2[5] wl1[6] wl2[6] wl1[7] wl2[7] wl1[8] wl2[8] wl1[9] wl2[9] wl1[10] wl2[10] wl1[11] wl2[11] wl1[12] wl2[12] wl1[13] wl2[13] wl1[14] wl2[14] wl1[15] wl2[15] wl1[16] wl2[16] wl1[17] wl2[17] wl1[18] wl2[18] wl1[19] wl2[19] wl1[20] wl2[20] wl1[21] wl2[21] wl1[22] wl2[22] wl1[23] wl2[23] wl1[24] wl2[24] wl1[25] wl2[25] wl1[26] wl2[26] wl1[27] wl2[27] wl1[28] wl2[28] wl1[29] wl2[29] wl1[30] wl2[30] wl1[31] wl2[31] wl1[32] wl2[32] wl1[33] wl2[33] wl1[34] wl2[34] wl1[35] wl2[35] wl1[36] wl2[36] wl1[37] wl2[37] wl1[38] wl2[38] wl1[39] wl2[39] wl1[40] wl2[40] wl1[41] wl2[41] wl1[42] wl2[42] wl1[43] wl2[43] wl1[44] wl2[44] wl1[45] wl2[45] wl1[46] wl2[46] wl1[47] wl2[47] wl1[48] wl2[48] wl1[49] wl2[49] wl1[50] wl2[50] wl1[51] wl2[51] wl1[52] wl2[52] wl1[53] wl2[53] wl1[54] wl2[54] wl1[55] wl2[55] wl1[56] wl2[56] wl1[57] wl2[57] wl1[58] wl2[58] wl1[59] wl2[59] wl1[60] wl2[60] wl1[61] wl2[61] wl1[62] wl2[62] wl1[63] wl2[63] wl1[64] wl2[64] wl1[65] wl2[65] wl1[66] wl2[66] wl1[67] wl2[67] wl1[68] wl2[68] wl1[69] wl2[69] wl1[70] wl2[70] wl1[71] wl2[71] wl1[72] wl2[72] wl1[73] wl2[73] wl1[74] wl2[74] wl1[75] wl2[75] wl1[76] wl2[76] wl1[77] wl2[77] wl1[78] wl2[78] wl1[79] wl2[79] wl1[80] wl2[80] wl1[81] wl2[81] wl1[82] wl2[82] wl1[83] wl2[83] wl1[84] wl2[84] wl1[85] wl2[85] wl1[86] wl2[86] wl1[87] wl2[87] wl1[88] wl2[88] wl1[89] wl2[89] wl1[90] wl2[90] wl1[91] wl2[91] wl1[92] wl2[92] wl1[93] wl2[93] wl1[94] wl2[94] wl1[95] wl2[95] wl1[96] wl2[96] wl1[97] wl2[97] wl1[98] wl2[98] wl1[99] wl2[99] wl1[100] wl2[100] wl1[101] wl2[101] wl1[102] wl2[102] wl1[103] wl2[103] wl1[104] wl2[104] wl1[105] wl2[105] wl1[106] wl2[106] wl1[107] wl2[107] wl1[108] wl2[108] wl1[109] wl2[109] wl1[110] wl2[110] wl1[111] wl2[111] wl1[112] wl2[112] wl1[113] wl2[113] wl1[114] wl2[114] wl1[115] wl2[115] wl1[116] wl2[116] wl1[117] wl2[117] wl1[118] wl2[118] wl1[119] wl2[119] wl1[120] wl2[120] wl1[121] wl2[121] wl1[122] wl2[122] wl1[123] wl2[123] wl1[124] wl2[124] wl1[125] wl2[125] wl1[126] wl2[126] wl1[127] wl2[127] q1[16] q2[23] d1[16] d2[23] q1[17] q2[22] d1[17] d2[22] q1[18] q2[21] d1[18] d2[21] q1[19] q2[20] d1[19] d2[20] q1[20] q2[19] d1[20] d2[19] q1[21] q2[18] d1[21] d2[18] q1[22] q2[17] d1[22] d2[17] q1[23] q2[16] d1[23] d2[16] we1[2] clk1 we_en1 precharge1_n we2[2] clk2 we_en2 precharge2_n mux1[0] mux2[0] mux1[1] mux2[1] mux1[2] mux2[2] mux1[3] mux2[3] DP8TColumn_128R8B4M
Xcolumn[3] vss vdd wl1[0] wl2[0] wl1[1] wl2[1] wl1[2] wl2[2] wl1[3] wl2[3] wl1[4] wl2[4] wl1[5] wl2[5] wl1[6] wl2[6] wl1[7] wl2[7] wl1[8] wl2[8] wl1[9] wl2[9] wl1[10] wl2[10] wl1[11] wl2[11] wl1[12] wl2[12] wl1[13] wl2[13] wl1[14] wl2[14] wl1[15] wl2[15] wl1[16] wl2[16] wl1[17] wl2[17] wl1[18] wl2[18] wl1[19] wl2[19] wl1[20] wl2[20] wl1[21] wl2[21] wl1[22] wl2[22] wl1[23] wl2[23] wl1[24] wl2[24] wl1[25] wl2[25] wl1[26] wl2[26] wl1[27] wl2[27] wl1[28] wl2[28] wl1[29] wl2[29] wl1[30] wl2[30] wl1[31] wl2[31] wl1[32] wl2[32] wl1[33] wl2[33] wl1[34] wl2[34] wl1[35] wl2[35] wl1[36] wl2[36] wl1[37] wl2[37] wl1[38] wl2[38] wl1[39] wl2[39] wl1[40] wl2[40] wl1[41] wl2[41] wl1[42] wl2[42] wl1[43] wl2[43] wl1[44] wl2[44] wl1[45] wl2[45] wl1[46] wl2[46] wl1[47] wl2[47] wl1[48] wl2[48] wl1[49] wl2[49] wl1[50] wl2[50] wl1[51] wl2[51] wl1[52] wl2[52] wl1[53] wl2[53] wl1[54] wl2[54] wl1[55] wl2[55] wl1[56] wl2[56] wl1[57] wl2[57] wl1[58] wl2[58] wl1[59] wl2[59] wl1[60] wl2[60] wl1[61] wl2[61] wl1[62] wl2[62] wl1[63] wl2[63] wl1[64] wl2[64] wl1[65] wl2[65] wl1[66] wl2[66] wl1[67] wl2[67] wl1[68] wl2[68] wl1[69] wl2[69] wl1[70] wl2[70] wl1[71] wl2[71] wl1[72] wl2[72] wl1[73] wl2[73] wl1[74] wl2[74] wl1[75] wl2[75] wl1[76] wl2[76] wl1[77] wl2[77] wl1[78] wl2[78] wl1[79] wl2[79] wl1[80] wl2[80] wl1[81] wl2[81] wl1[82] wl2[82] wl1[83] wl2[83] wl1[84] wl2[84] wl1[85] wl2[85] wl1[86] wl2[86] wl1[87] wl2[87] wl1[88] wl2[88] wl1[89] wl2[89] wl1[90] wl2[90] wl1[91] wl2[91] wl1[92] wl2[92] wl1[93] wl2[93] wl1[94] wl2[94] wl1[95] wl2[95] wl1[96] wl2[96] wl1[97] wl2[97] wl1[98] wl2[98] wl1[99] wl2[99] wl1[100] wl2[100] wl1[101] wl2[101] wl1[102] wl2[102] wl1[103] wl2[103] wl1[104] wl2[104] wl1[105] wl2[105] wl1[106] wl2[106] wl1[107] wl2[107] wl1[108] wl2[108] wl1[109] wl2[109] wl1[110] wl2[110] wl1[111] wl2[111] wl1[112] wl2[112] wl1[113] wl2[113] wl1[114] wl2[114] wl1[115] wl2[115] wl1[116] wl2[116] wl1[117] wl2[117] wl1[118] wl2[118] wl1[119] wl2[119] wl1[120] wl2[120] wl1[121] wl2[121] wl1[122] wl2[122] wl1[123] wl2[123] wl1[124] wl2[124] wl1[125] wl2[125] wl1[126] wl2[126] wl1[127] wl2[127] q1[24] q2[31] d1[24] d2[31] q1[25] q2[30] d1[25] d2[30] q1[26] q2[29] d1[26] d2[29] q1[27] q2[28] d1[27] d2[28] q1[28] q2[27] d1[28] d2[27] q1[29] q2[26] d1[29] d2[26] q1[30] q2[25] d1[30] d2[25] q1[31] q2[24] d1[31] d2[24] we1[3] clk1 we_en1 precharge1_n we2[3] clk2 we_en2 precharge2_n mux1[0] mux2[0] mux1[1] mux2[1] mux1[2] mux2[2] mux1[3] mux2[3] DP8TColumn_128R8B4M
.ends DP8TColumnBlock_128R32B4M4W

.subckt DP8TBlock_512x32_342A4WE clk1 clk2 a1[0] a2[0] a1[1] a2[1] a1[2] a2[2] a1[3] a2[3] a1[4] a2[4] a1[5] a2[5] a1[6] a2[6] a1[7] a2[7] a1[8] a2[8] vss vdd q1[0] q1[1] q1[2] q1[3] q1[4] q1[5] q1[6] q1[7] q1[8] q1[9] q1[10] q1[11] q1[12] q1[13] q1[14] q1[15] q1[16] q1[17] q1[18] q1[19] q1[20] q1[21] q1[22] q1[23] q1[24] q1[25] q1[26] q1[27] q1[28] q1[29] q1[30] q1[31] q2[0] q2[1] q2[2] q2[3] q2[4] q2[5] q2[6] q2[7] q2[8] q2[9] q2[10] q2[11] q2[12] q2[13] q2[14] q2[15] q2[16] q2[17] q2[18] q2[19] q2[20] q2[21] q2[22] q2[23] q2[24] q2[25] q2[26] q2[27] q2[28] q2[29] q2[30] q2[31] d1[0] d1[1] d1[2] d1[3] d1[4] d1[5] d1[6] d1[7] d1[8] d1[9] d1[10] d1[11] d1[12] d1[13] d1[14] d1[15] d1[16] d1[17] d1[18] d1[19] d1[20] d1[21] d1[22] d1[23] d1[24] d1[25] d1[26] d1[27] d1[28] d1[29] d1[30] d1[31] d2[0] d2[1] d2[2] d2[3] d2[4] d2[5] d2[6] d2[7] d2[8] d2[9] d2[10] d2[11] d2[12] d2[13] d2[14] d2[15] d2[16] d2[17] d2[18] d2[19] d2[20] d2[21] d2[22] d2[23] d2[24] d2[25] d2[26] d2[27] d2[28] d2[29] d2[30] d2[31] we1[0] we1[1] we1[2] we1[3] we2[0] we2[1] we2[2] we2[3]
Xrowperiph1 vss vdd clk1 a1[0] a1[1] a1[2] a1[3] a1[4] a1[5] a1[6] a1[7] a1[8] wl1[0] wl1[1] wl1[2] wl1[3] wl1[4] wl1[5] wl1[6] wl1[7] wl1[8] wl1[9] wl1[10] wl1[11] wl1[12] wl1[13] wl1[14] wl1[15] wl1[16] wl1[17] wl1[18] wl1[19] wl1[20] wl1[21] wl1[22] wl1[23] wl1[24] wl1[25] wl1[26] wl1[27] wl1[28] wl1[29] wl1[30] wl1[31] wl1[32] wl1[33] wl1[34] wl1[35] wl1[36] wl1[37] wl1[38] wl1[39] wl1[40] wl1[41] wl1[42] wl1[43] wl1[44] wl1[45] wl1[46] wl1[47] wl1[48] wl1[49] wl1[50] wl1[51] wl1[52] wl1[53] wl1[54] wl1[55] wl1[56] wl1[57] wl1[58] wl1[59] wl1[60] wl1[61] wl1[62] wl1[63] wl1[64] wl1[65] wl1[66] wl1[67] wl1[68] wl1[69] wl1[70] wl1[71] wl1[72] wl1[73] wl1[74] wl1[75] wl1[76] wl1[77] wl1[78] wl1[79] wl1[80] wl1[81] wl1[82] wl1[83] wl1[84] wl1[85] wl1[86] wl1[87] wl1[88] wl1[89] wl1[90] wl1[91] wl1[92] wl1[93] wl1[94] wl1[95] wl1[96] wl1[97] wl1[98] wl1[99] wl1[100] wl1[101] wl1[102] wl1[103] wl1[104] wl1[105] wl1[106] wl1[107] wl1[108] wl1[109] wl1[110] wl1[111] wl1[112] wl1[113] wl1[114] wl1[115] wl1[116] wl1[117] wl1[118] wl1[119] wl1[120] wl1[121] wl1[122] wl1[123] wl1[124] wl1[125] wl1[126] wl1[127] mux1[0] mux1[1] mux1[2] mux1[3] columnclk1 precharge1_n we_en1 DP8TRowPeriphery_3_4_2_wl1
Xrowperiph2 vss vdd clk2 a2[0] a2[1] a2[2] a2[3] a2[4] a2[5] a2[6] a2[7] a2[8] wl2[0] wl2[1] wl2[2] wl2[3] wl2[4] wl2[5] wl2[6] wl2[7] wl2[8] wl2[9] wl2[10] wl2[11] wl2[12] wl2[13] wl2[14] wl2[15] wl2[16] wl2[17] wl2[18] wl2[19] wl2[20] wl2[21] wl2[22] wl2[23] wl2[24] wl2[25] wl2[26] wl2[27] wl2[28] wl2[29] wl2[30] wl2[31] wl2[32] wl2[33] wl2[34] wl2[35] wl2[36] wl2[37] wl2[38] wl2[39] wl2[40] wl2[41] wl2[42] wl2[43] wl2[44] wl2[45] wl2[46] wl2[47] wl2[48] wl2[49] wl2[50] wl2[51] wl2[52] wl2[53] wl2[54] wl2[55] wl2[56] wl2[57] wl2[58] wl2[59] wl2[60] wl2[61] wl2[62] wl2[63] wl2[64] wl2[65] wl2[66] wl2[67] wl2[68] wl2[69] wl2[70] wl2[71] wl2[72] wl2[73] wl2[74] wl2[75] wl2[76] wl2[77] wl2[78] wl2[79] wl2[80] wl2[81] wl2[82] wl2[83] wl2[84] wl2[85] wl2[86] wl2[87] wl2[88] wl2[89] wl2[90] wl2[91] wl2[92] wl2[93] wl2[94] wl2[95] wl2[96] wl2[97] wl2[98] wl2[99] wl2[100] wl2[101] wl2[102] wl2[103] wl2[104] wl2[105] wl2[106] wl2[107] wl2[108] wl2[109] wl2[110] wl2[111] wl2[112] wl2[113] wl2[114] wl2[115] wl2[116] wl2[117] wl2[118] wl2[119] wl2[120] wl2[121] wl2[122] wl2[123] wl2[124] wl2[125] wl2[126] wl2[127] mux2[0] mux2[1] mux2[2] mux2[3] columnclk2 precharge2_n we_en2 DP8TRowPeriphery_3_4_2_wl2
Xcolumnblock vss vdd columnclk1 columnclk2 precharge1_n precharge2_n we_en1 we_en2 wl1[0] wl1[1] wl1[2] wl1[3] wl1[4] wl1[5] wl1[6] wl1[7] wl1[8] wl1[9] wl1[10] wl1[11] wl1[12] wl1[13] wl1[14] wl1[15] wl1[16] wl1[17] wl1[18] wl1[19] wl1[20] wl1[21] wl1[22] wl1[23] wl1[24] wl1[25] wl1[26] wl1[27] wl1[28] wl1[29] wl1[30] wl1[31] wl1[32] wl1[33] wl1[34] wl1[35] wl1[36] wl1[37] wl1[38] wl1[39] wl1[40] wl1[41] wl1[42] wl1[43] wl1[44] wl1[45] wl1[46] wl1[47] wl1[48] wl1[49] wl1[50] wl1[51] wl1[52] wl1[53] wl1[54] wl1[55] wl1[56] wl1[57] wl1[58] wl1[59] wl1[60] wl1[61] wl1[62] wl1[63] wl1[64] wl1[65] wl1[66] wl1[67] wl1[68] wl1[69] wl1[70] wl1[71] wl1[72] wl1[73] wl1[74] wl1[75] wl1[76] wl1[77] wl1[78] wl1[79] wl1[80] wl1[81] wl1[82] wl1[83] wl1[84] wl1[85] wl1[86] wl1[87] wl1[88] wl1[89] wl1[90] wl1[91] wl1[92] wl1[93] wl1[94] wl1[95] wl1[96] wl1[97] wl1[98] wl1[99] wl1[100] wl1[101] wl1[102] wl1[103] wl1[104] wl1[105] wl1[106] wl1[107] wl1[108] wl1[109] wl1[110] wl1[111] wl1[112] wl1[113] wl1[114] wl1[115] wl1[116] wl1[117] wl1[118] wl1[119] wl1[120] wl1[121] wl1[122] wl1[123] wl1[124] wl1[125] wl1[126] wl1[127] wl2[0] wl2[1] wl2[2] wl2[3] wl2[4] wl2[5] wl2[6] wl2[7] wl2[8] wl2[9] wl2[10] wl2[11] wl2[12] wl2[13] wl2[14] wl2[15] wl2[16] wl2[17] wl2[18] wl2[19] wl2[20] wl2[21] wl2[22] wl2[23] wl2[24] wl2[25] wl2[26] wl2[27] wl2[28] wl2[29] wl2[30] wl2[31] wl2[32] wl2[33] wl2[34] wl2[35] wl2[36] wl2[37] wl2[38] wl2[39] wl2[40] wl2[41] wl2[42] wl2[43] wl2[44] wl2[45] wl2[46] wl2[47] wl2[48] wl2[49] wl2[50] wl2[51] wl2[52] wl2[53] wl2[54] wl2[55] wl2[56] wl2[57] wl2[58] wl2[59] wl2[60] wl2[61] wl2[62] wl2[63] wl2[64] wl2[65] wl2[66] wl2[67] wl2[68] wl2[69] wl2[70] wl2[71] wl2[72] wl2[73] wl2[74] wl2[75] wl2[76] wl2[77] wl2[78] wl2[79] wl2[80] wl2[81] wl2[82] wl2[83] wl2[84] wl2[85] wl2[86] wl2[87] wl2[88] wl2[89] wl2[90] wl2[91] wl2[92] wl2[93] wl2[94] wl2[95] wl2[96] wl2[97] wl2[98] wl2[99] wl2[100] wl2[101] wl2[102] wl2[103] wl2[104] wl2[105] wl2[106] wl2[107] wl2[108] wl2[109] wl2[110] wl2[111] wl2[112] wl2[113] wl2[114] wl2[115] wl2[116] wl2[117] wl2[118] wl2[119] wl2[120] wl2[121] wl2[122] wl2[123] wl2[124] wl2[125] wl2[126] wl2[127] mux1[0] mux1[1] mux1[2] mux1[3] mux2[0] mux2[1] mux2[2] mux2[3] we1[0] we2[0] q1[0] q2[0] d1[0] d2[0] q1[1] q2[1] d1[1] d2[1] q1[2] q2[2] d1[2] d2[2] q1[3] q2[3] d1[3] d2[3] q1[4] q2[4] d1[4] d2[4] q1[5] q2[5] d1[5] d2[5] q1[6] q2[6] d1[6] d2[6] q1[7] q2[7] d1[7] d2[7] we1[1] we2[1] q1[8] q2[8] d1[8] d2[8] q1[9] q2[9] d1[9] d2[9] q1[10] q2[10] d1[10] d2[10] q1[11] q2[11] d1[11] d2[11] q1[12] q2[12] d1[12] d2[12] q1[13] q2[13] d1[13] d2[13] q1[14] q2[14] d1[14] d2[14] q1[15] q2[15] d1[15] d2[15] we1[2] we2[2] q1[16] q2[16] d1[16] d2[16] q1[17] q2[17] d1[17] d2[17] q1[18] q2[18] d1[18] d2[18] q1[19] q2[19] d1[19] d2[19] q1[20] q2[20] d1[20] d2[20] q1[21] q2[21] d1[21] d2[21] q1[22] q2[22] d1[22] d2[22] q1[23] q2[23] d1[23] d2[23] we1[3] we2[3] q1[24] q2[24] d1[24] d2[24] q1[25] q2[25] d1[25] d2[25] q1[26] q2[26] d1[26] d2[26] q1[27] q2[27] d1[27] d2[27] q1[28] q2[28] d1[28] d2[28] q1[29] q2[29] d1[29] d2[29] q1[30] q2[30] d1[30] d2[30] q1[31] q2[31] d1[31] d2[31] DP8TColumnBlock_128R32B4M4W
.ends DP8TBlock_512x32_342A4WE

.subckt DP8TTimingIn_9SF vss vdd sr_in sr_out sr_shift sr_latch i[8] i[7] i[6] i[5] i[4] i[3] i[2] i[1] i[0]
Xshiftff[8] vdd vss sr_in sr_shift i_s[8] dff_x1
Xshiftff[7] vdd vss i_s[8] sr_shift i_s[7] dff_x1
Xshiftff[6] vdd vss i_s[7] sr_shift i_s[6] dff_x1
Xshiftff[5] vdd vss i_s[6] sr_shift i_s[5] dff_x1
Xshiftff[4] vdd vss i_s[5] sr_shift i_s[4] dff_x1
Xshiftff[3] vdd vss i_s[4] sr_shift i_s[3] dff_x1
Xshiftff[2] vdd vss i_s[3] sr_shift i_s[2] dff_x1
Xshiftff[1] vdd vss i_s[2] sr_shift i_s[1] dff_x1
Xshiftff[0] vdd vss i_s[1] sr_shift sr_out dff_x1
Xlatchff[8] vdd vss i_s[8] sr_latch i[8] dff_x1
Xlatchff[7] vdd vss i_s[7] sr_latch i[7] dff_x1
Xlatchff[6] vdd vss i_s[6] sr_latch i[6] dff_x1
Xlatchff[5] vdd vss i_s[5] sr_latch i[5] dff_x1
Xlatchff[4] vdd vss i_s[4] sr_latch i[4] dff_x1
Xlatchff[3] vdd vss i_s[3] sr_latch i[3] dff_x1
Xlatchff[2] vdd vss i_s[2] sr_latch i[2] dff_x1
Xlatchff[1] vdd vss i_s[1] sr_latch i[1] dff_x1
Xlatchff[0] vdd vss sr_out sr_latch i[0] dff_x1
.ends DP8TTimingIn_9SF

.subckt DP8TTimingOut_2SL vss vdd sr_in sr_out sr_shift sr_latch l2s o[0] o[1]
Xshiftff[0] vdd vss o_m[0] sr_shift o_s[0] dff_x1
Xshiftff[1] vdd vss o_m[1] sr_shift sr_out dff_x1
Xlatchff[0] vdd vss o[0] sr_latch o_l[0] dff_x1
Xlatchff[1] vdd vss o[1] sr_latch o_l[1] dff_x1
Xmux[0] vdd vss sr_in o_l[0] l2s o_m[0] mux2_x1
Xmux[1] vdd vss o_s[0] o_l[1] l2s o_m[1] mux2_x1
.ends DP8TTimingOut_2SL

.subckt DP8TTimingIn_9SL vss vdd sr_in sr_out sr_shift sr_latch i[0] i[1] i[2] i[3] i[4] i[5] i[6] i[7] i[8]
Xshiftff[0] vdd vss sr_in sr_shift i_s[0] dff_x1
Xshiftff[1] vdd vss i_s[0] sr_shift i_s[1] dff_x1
Xshiftff[2] vdd vss i_s[1] sr_shift i_s[2] dff_x1
Xshiftff[3] vdd vss i_s[2] sr_shift i_s[3] dff_x1
Xshiftff[4] vdd vss i_s[3] sr_shift i_s[4] dff_x1
Xshiftff[5] vdd vss i_s[4] sr_shift i_s[5] dff_x1
Xshiftff[6] vdd vss i_s[5] sr_shift i_s[6] dff_x1
Xshiftff[7] vdd vss i_s[6] sr_shift i_s[7] dff_x1
Xshiftff[8] vdd vss i_s[7] sr_shift sr_out dff_x1
Xlatchff[0] vdd vss i_s[0] sr_latch i[0] dff_x1
Xlatchff[1] vdd vss i_s[1] sr_latch i[1] dff_x1
Xlatchff[2] vdd vss i_s[2] sr_latch i[2] dff_x1
Xlatchff[3] vdd vss i_s[3] sr_latch i[3] dff_x1
Xlatchff[4] vdd vss i_s[4] sr_latch i[4] dff_x1
Xlatchff[5] vdd vss i_s[5] sr_latch i[5] dff_x1
Xlatchff[6] vdd vss i_s[6] sr_latch i[6] dff_x1
Xlatchff[7] vdd vss i_s[7] sr_latch i[7] dff_x1
Xlatchff[8] vdd vss sr_out sr_latch i[8] dff_x1
.ends DP8TTimingIn_9SL

.subckt DP8TTimingOut_8SL vss vdd sr_in sr_out sr_shift sr_latch l2s o[0] o[1] o[2] o[3] o[4] o[5] o[6] o[7]
Xshiftff[0] vdd vss o_m[0] sr_shift o_s[0] dff_x1
Xshiftff[1] vdd vss o_m[1] sr_shift o_s[1] dff_x1
Xshiftff[2] vdd vss o_m[2] sr_shift o_s[2] dff_x1
Xshiftff[3] vdd vss o_m[3] sr_shift o_s[3] dff_x1
Xshiftff[4] vdd vss o_m[4] sr_shift o_s[4] dff_x1
Xshiftff[5] vdd vss o_m[5] sr_shift o_s[5] dff_x1
Xshiftff[6] vdd vss o_m[6] sr_shift o_s[6] dff_x1
Xshiftff[7] vdd vss o_m[7] sr_shift sr_out dff_x1
Xlatchff[0] vdd vss o[0] sr_latch o_l[0] dff_x1
Xlatchff[1] vdd vss o[1] sr_latch o_l[1] dff_x1
Xlatchff[2] vdd vss o[2] sr_latch o_l[2] dff_x1
Xlatchff[3] vdd vss o[3] sr_latch o_l[3] dff_x1
Xlatchff[4] vdd vss o[4] sr_latch o_l[4] dff_x1
Xlatchff[5] vdd vss o[5] sr_latch o_l[5] dff_x1
Xlatchff[6] vdd vss o[6] sr_latch o_l[6] dff_x1
Xlatchff[7] vdd vss o[7] sr_latch o_l[7] dff_x1
Xmux[0] vdd vss sr_in o_l[0] l2s o_m[0] mux2_x1
Xmux[1] vdd vss o_s[0] o_l[1] l2s o_m[1] mux2_x1
Xmux[2] vdd vss o_s[1] o_l[2] l2s o_m[2] mux2_x1
Xmux[3] vdd vss o_s[2] o_l[3] l2s o_m[3] mux2_x1
Xmux[4] vdd vss o_s[3] o_l[4] l2s o_m[4] mux2_x1
Xmux[5] vdd vss o_s[4] o_l[5] l2s o_m[5] mux2_x1
Xmux[6] vdd vss o_s[5] o_l[6] l2s o_m[6] mux2_x1
Xmux[7] vdd vss o_s[6] o_l[7] l2s o_m[7] mux2_x1
.ends DP8TTimingOut_8SL

.subckt DP8TBlock_512x32_342A4WE_Test vss vdd_block vdd_periph clk1 clk2 in_shift1 in_shift2 in_latch1 in_latch2 in_srin1 in_srin2 in_srout1 in_srout2 out_shift1 out_shift2 out_latch1 out_latch2 out_l2s1 out_l2s2 out_srin1 out_srin2 out_srout1 out_srout2
Xblock clk1 clk2 a1[0] a2[0] a1[1] a2[1] a1[2] a2[2] a1[3] a2[3] a1[4] a2[4] a1[5] a2[5] a1[6] a2[6] a1[7] a2[7] a1[8] a2[8] vss vdd_block q1[0] q1[1] q1[2] q1[3] q1[4] q1[5] q1[6] q1[7] q1[8] q1[9] q1[10] q1[11] q1[12] q1[13] q1[14] q1[15] q1[16] q1[17] q1[18] q1[19] q1[20] q1[21] q1[22] q1[23] q1[24] q1[25] q1[26] q1[27] q1[28] q1[29] q1[30] q1[31] q2[0] q2[1] q2[2] q2[3] q2[4] q2[5] q2[6] q2[7] q2[8] q2[9] q2[10] q2[11] q2[12] q2[13] q2[14] q2[15] q2[16] q2[17] q2[18] q2[19] q2[20] q2[21] q2[22] q2[23] q2[24] q2[25] q2[26] q2[27] q2[28] q2[29] q2[30] q2[31] d1[0] d1[1] d1[2] d1[3] d1[4] d1[5] d1[6] d1[7] d1[8] d1[9] d1[10] d1[11] d1[12] d1[13] d1[14] d1[15] d1[16] d1[17] d1[18] d1[19] d1[20] d1[21] d1[22] d1[23] d1[24] d1[25] d1[26] d1[27] d1[28] d1[29] d1[30] d1[31] d2[0] d2[1] d2[2] d2[3] d2[4] d2[5] d2[6] d2[7] d2[8] d2[9] d2[10] d2[11] d2[12] d2[13] d2[14] d2[15] d2[16] d2[17] d2[18] d2[19] d2[20] d2[21] d2[22] d2[23] d2[24] d2[25] d2[26] d2[27] d2[28] d2[29] d2[30] d2[31] we1[0] we1[1] we1[2] we1[3] we2[0] we2[1] we2[2] we2[3] DP8TBlock_512x32_342A4WE
Xasr1 vss vdd_periph in_srin1 in_srconn1[0] in_shift1 in_latch1 a1[8] a1[7] a1[6] a1[5] a1[4] a1[3] a1[2] a1[1] a1[0] DP8TTimingIn_9SF
Xasr2 vss vdd_periph in_srin2 in_srconn2[0] in_shift2 in_latch2 a2[8] a2[7] a2[6] a2[5] a2[4] a2[3] a2[2] a2[1] a2[0] DP8TTimingIn_9SF
Xclksr1 vss vdd_periph out_srin1 out_srconn1[0] out_shift1 clk1 out_l2s1 in_latch1 out_latch1 DP8TTimingOut_2SL
Xclksr2 vss vdd_periph out_srin2 out_srconn2[0] out_shift2 clk2 out_l2s2 in_latch2 out_latch2 DP8TTimingOut_2SL
Xdwesr1[0] vss vdd_periph in_srconn1[0] in_srconn1[1] in_shift1 in_latch1 d1[0] d1[1] d1[2] d1[3] d1[4] d1[5] d1[6] d1[7] we1[0] DP8TTimingIn_9SL
Xdwesr1[1] vss vdd_periph in_srconn1[1] in_srconn1[2] in_shift1 in_latch1 d1[8] d1[9] d1[10] d1[11] d1[12] d1[13] d1[14] d1[15] we1[1] DP8TTimingIn_9SL
Xdwesr1[2] vss vdd_periph in_srconn1[2] in_srconn1[3] in_shift1 in_latch1 d1[16] d1[17] d1[18] d1[19] d1[20] d1[21] d1[22] d1[23] we1[2] DP8TTimingIn_9SL
Xdwesr1[3] vss vdd_periph in_srconn1[3] in_srout1 in_shift1 in_latch1 d1[24] d1[25] d1[26] d1[27] d1[28] d1[29] d1[30] d1[31] we1[3] DP8TTimingIn_9SL
Xdwesr2[0] vss vdd_periph in_srconn2[3] in_srout2 in_shift2 in_latch2 d2[7] d2[6] d2[5] d2[4] d2[3] d2[2] d2[1] d2[0] we2[0] DP8TTimingIn_9SL
Xdwesr2[1] vss vdd_periph in_srconn2[2] in_srconn2[3] in_shift2 in_latch2 d2[15] d2[14] d2[13] d2[12] d2[11] d2[10] d2[9] d2[8] we2[1] DP8TTimingIn_9SL
Xdwesr2[2] vss vdd_periph in_srconn2[1] in_srconn2[2] in_shift2 in_latch2 d2[23] d2[22] d2[21] d2[20] d2[19] d2[18] d2[17] d2[16] we2[2] DP8TTimingIn_9SL
Xdwesr2[3] vss vdd_periph in_srconn2[0] in_srconn2[1] in_shift2 in_latch2 d2[31] d2[30] d2[29] d2[28] d2[27] d2[26] d2[25] d2[24] we2[3] DP8TTimingIn_9SL
Xqsr1[0] vss vdd_periph out_srconn1[0] out_srconn1[1] out_shift1 out_latch1 out_l2s1 q1[0] q1[1] q1[2] q1[3] q1[4] q1[5] q1[6] q1[7] DP8TTimingOut_8SL
Xqsr1[1] vss vdd_periph out_srconn1[1] out_srconn1[2] out_shift1 out_latch1 out_l2s1 q1[8] q1[9] q1[10] q1[11] q1[12] q1[13] q1[14] q1[15] DP8TTimingOut_8SL
Xqsr1[2] vss vdd_periph out_srconn1[2] out_srconn1[3] out_shift1 out_latch1 out_l2s1 q1[16] q1[17] q1[18] q1[19] q1[20] q1[21] q1[22] q1[23] DP8TTimingOut_8SL
Xqsr1[3] vss vdd_periph out_srconn1[3] out_srout1 out_shift1 out_latch1 out_l2s1 q1[24] q1[25] q1[26] q1[27] q1[28] q1[29] q1[30] q1[31] DP8TTimingOut_8SL
Xqsr2[0] vss vdd_periph out_srconn2[3] out_srout2 out_shift2 out_latch2 out_l2s2 q2[7] q2[6] q2[5] q2[4] q2[3] q2[2] q2[1] q2[0] DP8TTimingOut_8SL
Xqsr2[1] vss vdd_periph out_srconn2[2] out_srconn2[3] out_shift2 out_latch2 out_l2s2 q2[15] q2[14] q2[13] q2[12] q2[11] q2[10] q2[9] q2[8] DP8TTimingOut_8SL
Xqsr2[2] vss vdd_periph out_srconn2[1] out_srconn2[2] out_shift2 out_latch2 out_l2s2 q2[23] q2[22] q2[21] q2[20] q2[19] q2[18] q2[17] q2[16] DP8TTimingOut_8SL
Xqsr2[3] vss vdd_periph out_srconn2[0] out_srconn2[1] out_shift2 out_latch2 out_l2s2 q2[31] q2[30] q2[29] q2[28] q2[27] q2[26] q2[25] q2[24] DP8TTimingOut_8SL
Xfill[0] vdd_periph vss fill_w2
Xfill[1] vdd_periph vss fill_w2
Xfill[2] vdd_periph vss fill_w2
Xfill[3] vdd_periph vss fill_w2
Xfill[4] vdd_periph vss fill_w2
Xfill[5] vdd_periph vss fill_w2
Xfill[6] vdd_periph vss fill_w2
Xfill[7] vdd_periph vss fill_w2
.ends DP8TBlock_512x32_342A4WE_Test

.subckt PadFrame_DP01 PAD0x0 PAD0x1 PAD0x2 PAD0x3 PAD0x4 PAD0x5 PAD0x6 PAD0x7 PAD0x8 PAD0x9 PAD1x0 PAD1x1 PAD1x2 PAD1x3 PAD1x4 PAD1x5 PAD1x6 PAD1x7 PAD1x8 PAD1x9
XPAD0x0 PAD0x0 BondPad
XPAD0x1 PAD0x1 BondPad
XPAD0x2 PAD0x2 BondPad
XPAD0x3 PAD0x3 BondPad
XPAD0x4 PAD0x4 BondPad
XPAD0x5 PAD0x5 BondPad
XPAD0x6 PAD0x6 BondPad
XPAD0x7 PAD0x7 BondPad
XPAD0x8 PAD0x8 BondPad
XPAD0x9 PAD0x9 BondPad
XPAD1x0 PAD1x0 BondPad
XPAD1x1 PAD1x1 BondPad
XPAD1x2 PAD1x2 BondPad
XPAD1x3 PAD1x3 BondPad
XPAD1x4 PAD1x4 BondPad
XPAD1x5 PAD1x5 BondPad
XPAD1x6 PAD1x6 BondPad
XPAD1x7 PAD1x7 BondPad
XPAD1x8 PAD1x8 BondPad
XPAD1x9 PAD1x9 BondPad
.ends PadFrame_DP01

.subckt DP01 vss vdd_periph vdd_block in_srout1 out_srout1 clk1 out_latch1 out_shift1 out_l2s out_srin in_shift1 in_srin in_latch1 in_latch2 in_srout2 in_shift2 out_srout2 out_shift2 clk2 out_latch2
Xtestblock vss vdd_block vdd_periph clk1 clk2 in_shift1 in_shift2 in_latch1 in_latch2 in_srin in_srin in_srout1 in_srout2 out_shift1 out_shift2 out_latch1 out_latch2 out_l2s out_l2s out_srin out_srin out_srout1 out_srout2 DP8TBlock_512x32_342A4WE_Test
Xpadframe vdd_block vss clk1 out_shift1 out_srin in_srin in_latch1 in_shift2 out_shift2 clk2 vdd_periph in_srout1 out_srout1 out_latch1 out_l2s in_shift1 in_latch2 in_srout2 out_srout2 out_latch2 PadFrame_DP01
.ends DP01

.subckt fill vdd vss
.ends fill

.subckt SRAMBlocksTest vss vdd iovss iovdd srin_int sp6t1_vdd sp6t1_clk sp6t1_in_shift sp6t1_in_latch sp6t1_in_srout sp6t1_out_shift sp6t1_out_latch sp6t1_out_l2s sp6t1_out_srout sp6t1_vss_frame sp6t1_vdd_periph_frame sp6t1_vdd_block_frame sp6t1_clk_frame sp6t1_in_shift_frame sp6t1_in_latch_frame sp6t1_in_srin_frame sp6t1_in_srout_frame sp6t1_out_shift_frame sp6t1_out_latch_frame sp6t1_out_l2s_frame sp6t1_out_srin_frame sp6t1_out_srout_frame sp6t2_vdd sp6t2_clk sp6t2_in_shift sp6t2_in_latch sp6t2_in_srout sp6t2_out_shift sp6t2_out_latch sp6t2_out_l2s sp6t2_out_srout sp6t2_vss_frame sp6t2_vdd_periph_frame sp6t2_vdd_block_frame sp6t2_clk_frame sp6t2_in_shift_frame sp6t2_in_latch_frame sp6t2_in_srin_frame sp6t2_in_srout_frame sp6t2_out_shift_frame sp6t2_out_latch_frame sp6t2_out_l2s_frame sp6t2_out_srin_frame sp6t2_out_srout_frame sp6t3_vdd sp6t3_clk sp6t3_in_shift sp6t3_in_latch sp6t3_in_srout sp6t3_out_shift sp6t3_out_latch sp6t3_out_l2s sp6t3_out_srout sp6t3_vss_frame sp6t3_vdd_periph_frame sp6t3_vdd_block_frame sp6t3_clk_frame sp6t3_in_shift_frame sp6t3_in_latch_frame sp6t3_in_srin_frame sp6t3_in_srout_frame sp6t3_out_shift-frame sp6t3_out_latch_frame sp6t3_out_l2s_frame sp6t3_out_srin_frame sp6t3_out_srout_frame dp8t1_vdd dp8t1_clk1 dp8t1_in_shift1 dp8t1_in_latch1 dp8t1_in_srout1 dp8t1_out_shift1 dp8t1_out_latch1 dp8t1_out_l2s1 dp8t1_out_srout1 dp8t1_clk2 dp8t1_in_shift2 dp8t1_in_latch2 dp8t1_in_srout2 dp8t1_out_shift2 dp8t1_out_latch2 dp8t1_out_l2s2 dp8t1_out_srout2 dp8t1_vss_frame dp8t1_vdd_periph_frame dp8t1_vdd_block_frame dp8t1_clk1_frame dp8t1_in_shift1_frame dp8t1_in_latch1_frame dp8t1_in_srin_frame dp8t1_in_srout1_frame dp8t1_out_shift1_frame dp8t1_out_latch1_frame dp8t1_out_l2s_frame dp8t1_out_srin_frame dp8t1_out_srout1_frame dp8t1_clk2_frame dp8t1_in_shift2_frame dp8t1_in_latch2_frame dp8t1_in_srout2_frame dp8t1_out_shift2_frame dp8t1_out_latch2_frame dp8t1_out_srout2_frame
Xsp6t1 vss sp6t1_vdd vdd sp6t1_clk_int sp6t1_in_shift_int sp6t1_in_latch_int srin_int sp6t1_in_srout_int sp6t1_out_shift_int sp6t1_out_latch_int sp6t1_out_l2s_int srin_int sp6t1_out_srout_int SP6TBlock_128x8_322A1WE_Test
Xsp6t1frame sp6t1_vss_frame sp6t1_vdd_periph_frame sp6t1_vdd_block_frame sp6t1_in_srout_frame sp6t1_out_srout_frame sp6t1_clk_frame sp6t1_out_latch_frame sp6t1_out_shift_frame sp6t1_out_l2s_frame sp6t1_out_srin_frame sp6t1_in_shift_frame sp6t1_in_srin_frame sp6t1_in_latch_frame SP01
Xsp6t2 vss sp6t2_vdd vdd sp6t2_clk_int sp6t2_in_shift_int sp6t2_in_latch_int srin_int sp6t2_in_srout_int sp6t2_out_shift_int sp6t2_out_latch_int sp6t2_out_l2s_int srin_int sp6t2_out_srout_int SP6TBlock_256x16_332A2WE_Test
Xsp6t2frame sp6t2_vss_frame sp6t2_vdd_periph_frame sp6t2_vdd_block_frame sp6t2_in_srout_frame sp6t2_out_srout_frame sp6t2_clk_frame sp6t2_out_latch_frame sp6t2_out_shift_frame sp6t2_out_l2s_frame sp6t2_out_srin_frame sp6t2_in_shift_frame sp6t2_in_srin_frame sp6t2_in_latch_frame SP02
Xsp6t3 vss sp6t3_vdd vdd sp6t3_clk_int sp6t3_in_shift_int sp6t3_in_latch_int srin_int sp6t3_in_srout_int sp6t3_out_shift_int sp6t3_out_latch_int sp6t3_out_l2s_int srin_int sp6t3_out_srout_int SP6TBlock_512x32_342A4WE_Test
Xsp6t3frame sp6t3_vss_frame sp6t3_vdd_periph_frame sp6t3_vdd_block_frame sp6t3_in_srout_frame sp6t3_out_srout_frame sp6t3_clk_frame sp6t3_out_latch_frame sp6t3_out_shift-frame sp6t3_out_l2s_frame sp6t3_out_srin_frame sp6t3_in_shift_frame sp6t3_in_srin_frame sp6t3_in_latch_frame SP03
Xdp8t1 vss dp8t1_vdd vdd dp8t1_clk1_int dp8t1_clk2_int dp8t1_in_shift1_int dp8t1_in_shift2_int dp8t1_in_latch1_int dp8t1_in_latch2_int srin_int srin_int dp8t1_in_srout1_int dp8t1_in_srout2_int dp8t1_out_shift1_int dp8t1_out_shift2_int dp8t1_out_latch1_int dp8t1_out_latch2_int dp8t1_out_l2s1_int dp8t1_out_l2s2_int srin_int srin_int dp8t1_out_srout1_int dp8t1_out_srout2_int DP8TBlock_512x32_342A4WE_Test
Xdp8t1frame dp8t1_vss_frame dp8t1_vdd_periph_frame dp8t1_vdd_block_frame dp8t1_in_srout1_frame dp8t1_out_srout1_frame dp8t1_clk1_frame dp8t1_out_latch1_frame dp8t1_out_shift1_frame dp8t1_out_l2s_frame dp8t1_out_srin_frame dp8t1_in_shift1_frame dp8t1_in_srin_frame dp8t1_in_latch1_frame dp8t1_in_latch2_frame dp8t1_in_srout2_frame dp8t1_in_shift2_frame dp8t1_out_srout2_frame dp8t1_out_shift2_frame dp8t1_clk2_frame dp8t1_out_latch2_frame DP01
Xsrin_buf vdd vss srin_io srin_int buf_x2
Xsrin_fill0 vdd vss fill
Xsrin_fill1 vdd vss fill
.ends SRAMBlocksTest
